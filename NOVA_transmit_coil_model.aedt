# Ansys Electronics Desktop project, version 2023.1
materials:
  Material250: permittivity=80 conductivity=1 delta_H_freq=300MHz
  copper: permeability=0.999991 conductivity=58000000
  vacuum: permittivity=1

design NOVA_transmit_coil_model_3_current_sources (HFSS, HFSS Modal Network, model units mm)
options: Save_Adaptive_support_files
variables:
  rout = (350/2) mm
  h = 173mm
  rin = (285/2) mm
  sw = (360*stw)/(2*rout*pi) deg
  stw = 12mm
  htw = 6mm
  hw = (htw*360)/(rout*2*pi) deg
  htw2 = 17mm
  hw2 = (htw2*360)/(rout*2*pi) deg
  rp = (164/2) mm
  stt = 360deg
  aa = 0
  aaa = -5*(360/8) deg
  PI1 = 0deg
  PI2 = 0deg
  PI3 = 0deg
  PI4 = 0deg
  PI5 = 0deg
  PI6 = 0deg
  PI7 = 0deg
  PI8 = 0deg
  UM1 = 10mA
  LM1 = 0mA
  MM1 = 0mA
  UM2 = 0mA
  LM2 = 0mA
  MM2 = 0mA
  UM3 = 0mA
  LM3 = 0mA
  MM3 = 0mA
  UM4 = 0mA
  LM4 = 0mA
  MM4 = 0mA
  UM5 = 0mA
  LM5 = 0mA
  MM5 = 0mA
  UM6 = 0mA
  LM6 = 0mA
  MM6 = 0mA
  UM7 = 0mA
  LM7 = 0mA
  MM7 = 0mA
  UM8 = 0mA
  LM8 = 0mA
  MM8 = 0mA
  UP1 = 0deg
  LP1 = 0deg
  MP1 = 0deg
  UP2 = 0deg
  LP2 = 0deg
  MP2 = 0deg
  UP3 = 0deg
  LP3 = 0deg
  MP3 = 0deg
  UP4 = 0deg
  LP4 = 0deg
  MP4 = 0deg
  UP5 = 0deg
  LP5 = 0deg
  MP5 = 0deg
  UP6 = 0deg
  LP6 = 0deg
  MP6 = 0deg
  UP7 = 0deg
  LP7 = 0deg
  MP7 = 0deg
  UP8 = 0deg
  LP8 = 0deg
  MP8 = 0deg
geometry:
  Rectangle1 = rectangle(corner=(rout, 0mm, -h/2), z_size=h, x_size=-rout+rin)
  Rectangle1.sweep_around_axis(axis=Z, angle=sw)
  Rectangle1_1 = Rectangle1.duplicate_around_axis(axis=Z, angle=sw+hw, total=2)
  Rectangle1_2 = Rectangle1.duplicate_around_axis(axis=Z, angle=hw+hw2+2*sw, total=2)
  Rectangle1_1_1 = Rectangle1_1.duplicate_around_axis(axis=Z, angle=hw+hw2+2*sw, total=2)
  Source1_1 = object_from(Rectangle1.face(#43))
  Source2_1 = object_from(Rectangle1_1.face(1 of 6))
  Source3_1 = object_from(Rectangle1_2.face(1 of 6))
  Source4_1 = object_from(Rectangle1_1_1.face(1 of 6))
  Source4_2 = object_from(Rectangle1_1_1.face(3 of 6))
  Source3_2 = object_from(Rectangle1_2.face(3 of 6))
  Source2_2 = object_from(Rectangle1_1.face(3 of 6))
  Source1_2 = object_from(Rectangle1.face(#45))
  strip4_1, strip4_2 = object_from(Rectangle1_1_1.face(4 of 6, 2 of 6))
  Rectangle1_1_1.delete()
  strip3_1, strip3_2 = object_from(Rectangle1_2.face(4 of 6, 2 of 6))
  Rectangle1_2.delete()
  strip2_1, strip2_2 = object_from(Rectangle1_1.face(4 of 6, 2 of 6))
  Rectangle1_1.delete()
  strip1_1, strip1_2 = object_from(Rectangle1.face(#46, #44))
  Rectangle1.delete()
  phantom1 [Material250] = sphere(centre=(0mm, 0mm, 0mm), radius=rp)
  Rectangle2 = rectangle(corner=(-225mm, 225mm, 0mm), x_size=450mm, y_size=-450mm)
  [Source1_1, Source2_1, Source3_1, Source4_1, Source4_2, Source3_2, Source2_2, Source1_2, strip4_1, strip4_2, strip3_1, strip3_2, strip2_1, strip2_2, strip1_1, strip1_2].rotate(axis=Z, angle=-(2*sw+hw+hw2/2))
  [Source1_1, Source2_1, Source3_1, Source4_1, Source4_2, Source3_2, Source2_2, Source1_2, strip4_1, strip4_2, strip3_1, strip3_2, strip2_1, strip2_2, strip1_1, strip1_2].rotate(axis=Z, angle=((stt-8*(4*sw+hw2+2*hw))/16)+2*sw+hw+hw2/2)
  Polyline2 = polyline((137.12405mm, 38.771716mm, 86.5mm) (138.37251mm, 34.048455mm, 86.5mm))
  Polyline2_1 = Polyline2.duplicate_along_line(step=(0mm, 0mm, -stw), total=2)
  Polyline2.connect(Polyline2_1)
  Polyline3 = polyline((128.84989mm, 60.860128mm, 86.5mm) (134.14524mm, 48.076024mm, 86.5mm))
  Polyline3_1 = Polyline3.duplicate_along_line(step=(0mm, 0mm, -stw), total=2)
  Polyline3.connect(Polyline3_1)
  Polyline4 = polyline((124.37709mm, 69.545599mm, 86.5mm) (121.92004mm, 73.768249mm, 86.5mm))
  Polyline4_1 = Polyline4.duplicate_along_line(step=(0mm, 0mm, -stw), total=2)
  Polyline4_1.connect(Polyline4)
  Polyline6 = polyline((121.92004mm, 73.768249mm, -86.5mm) (124.37709mm, 69.545599mm, -86.5mm))
  Polyline6_1 = Polyline6.duplicate_along_line(step=(0mm, 0mm, stw), total=2)
  Polyline6_1.connect(Polyline6)
  Polyline7 = polyline((128.84989mm, 60.860128mm, -86.5mm) (134.14524mm, 48.076024mm, -86.5mm))
  Polyline7_1 = Polyline7.duplicate_along_line(step=(0mm, 0mm, stw), total=2)
  Polyline7_1.connect(Polyline7)
  Polyline8 = polyline((137.12405mm, 38.771716mm, -86.5mm) (138.37251mm, 34.048455mm, -86.5mm))
  Polyline8_1 = Polyline8.duplicate_along_line(step=(0mm, 0mm, stw), total=2)
  Polyline8_1.connect(Polyline8)
  Rectangle3 = rectangle(corner=(-225mm, 225mm, 0mm), x_size=450mm, y_size=-450mm)
  Rectangle2_119 [non-model] = Rectangle3.duplicate_around_axis(axis=X, angle=90deg, total=2)
  Rectangle3.delete()
  Rectangle2_119_1 [non-model] = Rectangle2_119.duplicate_around_axis(axis=Z, angle=90deg, total=2)
  strip1_1_ObjectFromEdge1 [non-model] = object_from(strip1_1.edge(2 of 4))
  strip1_1_ObjectFromEdge1.move(-5.6843419e-14mm, -7.1054274e-15mm, -86.5mm)
  strip2_1_ObjectFromEdge1 [non-model] = object_from(strip2_1.edge(2 of 4))
  strip2_1_ObjectFromEdge1.move(-2.8421709e-14mm, -2.1316282e-14mm, -86.5mm)
  strip3_1_ObjectFromEdge1 [non-model] = object_from(strip3_1.edge(2 of 4))
  strip3_1_ObjectFromEdge1.move(-2.8421709e-14mm, -1.4210855e-14mm, -86.5mm)
  strip4_1_ObjectFromEdge1 [non-model] = object_from(strip4_1.edge(2 of 4))
  strip4_1_ObjectFromEdge1.move(-2.8421709e-14mm, -1.4210855e-14mm, -86.5mm)
  strip1_2_ObjectFromEdge1 [non-model] = object_from(strip1_2.edge(4 of 4))
  strip1_2_ObjectFromEdge1.move(-2.8421709e-14mm, -1.4210855e-14mm, -86.5mm)
  strip2_2_ObjectFromEdge1 [non-model] = object_from(strip2_2.edge(4 of 4))
  strip2_2_ObjectFromEdge1.move(-2.8421709e-14mm, -2.1316282e-14mm, -86.5mm)
  strip3_2_ObjectFromEdge1 [non-model] = object_from(strip3_2.edge(4 of 4))
  strip3_2_ObjectFromEdge1.move(-2.8421709e-14mm, -2.8421709e-14mm, -86.5mm)
  strip4_2_ObjectFromEdge1 [non-model] = object_from(strip4_2.edge(4 of 4))
  strip4_2_ObjectFromEdge1.move(-2.8421709e-14mm, -2.8421709e-14mm, -86.5mm)
  [Source1_1, Source2_1, Source3_1, Source4_1, Source4_2, Source3_2, Source2_2, Source1_2, strip4_1, strip4_2, strip3_1, strip3_2, strip2_1, strip2_2, strip1_1, strip1_2, Polyline2, Polyline3, Polyline4_1, Polyline6_1, Polyline7_1, Polyline8_1, strip1_1_ObjectFromEdge1, strip2_1_ObjectFromEdge1, strip3_1_ObjectFromEdge1, strip4_1_ObjectFromEdge1, strip1_2_ObjectFromEdge1, strip2_2_ObjectFromEdge1, strip3_2_ObjectFromEdge1, strip4_2_ObjectFromEdge1].rotate(axis=Z, angle=-aa*(((stt-8*(4*sw+hw2+2*hw))/16)+2*sw+hw+hw2/2))
  [Source1_1, Source2_1, Source3_1, Source4_1, Source4_2, Source3_2, Source2_2, Source1_2, strip4_1, strip4_2, strip3_1, strip3_2, strip2_1, strip2_2, strip1_1, strip1_2, Polyline2, Polyline3, Polyline4_1, Polyline6_1, Polyline7_1, Polyline8_1, strip1_1_ObjectFromEdge1, strip2_1_ObjectFromEdge1, strip3_1_ObjectFromEdge1, strip4_1_ObjectFromEdge1, strip1_2_ObjectFromEdge1, strip2_2_ObjectFromEdge1, strip3_2_ObjectFromEdge1, strip4_2_ObjectFromEdge1].rotate(axis=Z, angle=(-360/8) deg)
  [Source1_1, Source2_1, Source3_1, Source4_1, Source4_2, Source3_2, Source2_2, Source1_2, strip4_1, strip4_2, strip3_1, strip3_2, strip2_1, strip2_2, strip1_1, strip1_2, Polyline2, Polyline3, Polyline4_1, Polyline6_1, Polyline7_1, Polyline8_1, strip1_1_ObjectFromEdge1, strip2_1_ObjectFromEdge1, strip3_1_ObjectFromEdge1, strip4_1_ObjectFromEdge1, strip1_2_ObjectFromEdge1, strip2_2_ObjectFromEdge1, strip3_2_ObjectFromEdge1, strip4_2_ObjectFromEdge1].rotate(axis=Z, angle=aaa)
  Region [vacuum] = region(absolute_offset=15cm on all sides)
  Source1_1.duplicate_around_axis(axis=Z, angle=(360/8) deg, total=8, attached)
  Source2_1.duplicate_around_axis(axis=Z, angle=(360/8) deg, total=8, attached)
  Source3_1.duplicate_around_axis(axis=Z, angle=(360/8) deg, total=8, attached)
  Source4_1.duplicate_around_axis(axis=Z, angle=(360/8) deg, total=8, attached)
  Source4_2.duplicate_around_axis(axis=Z, angle=(360/8) deg, total=8, attached)
  Source3_2.duplicate_around_axis(axis=Z, angle=(360/8) deg, total=8, attached)
  Source2_2.duplicate_around_axis(axis=Z, angle=(360/8) deg, total=8, attached)
  Source1_2.duplicate_around_axis(axis=Z, angle=(360/8) deg, total=8, attached)
  strip4_1.duplicate_around_axis(axis=Z, angle=(360/8) deg, total=8, attached)
  strip4_2.duplicate_around_axis(axis=Z, angle=(360/8) deg, total=8, attached)
  strip3_1.duplicate_around_axis(axis=Z, angle=(360/8) deg, total=8, attached)
  strip3_2.duplicate_around_axis(axis=Z, angle=(360/8) deg, total=8, attached)
  strip2_1.duplicate_around_axis(axis=Z, angle=(360/8) deg, total=8, attached)
  strip2_2.duplicate_around_axis(axis=Z, angle=(360/8) deg, total=8, attached)
  strip1_1.duplicate_around_axis(axis=Z, angle=(360/8) deg, total=8, attached)
  strip1_2.duplicate_around_axis(axis=Z, angle=(360/8) deg, total=8, attached)
  Polyline2.duplicate_around_axis(axis=Z, angle=(360/8) deg, total=8, attached)
  Polyline3.duplicate_around_axis(axis=Z, angle=(360/8) deg, total=8, attached)
  Polyline4_1.duplicate_around_axis(axis=Z, angle=(360/8) deg, total=8, attached)
  Polyline6_1.duplicate_around_axis(axis=Z, angle=(360/8) deg, total=8, attached)
  Polyline7_1.duplicate_around_axis(axis=Z, angle=(360/8) deg, total=8, attached)
  Polyline8_1.duplicate_around_axis(axis=Z, angle=(360/8) deg, total=8, attached)
  strip1_1_ObjectFromEdge1.duplicate_around_axis(axis=Z, angle=(360/8) deg, total=8, attached)
  strip2_1_ObjectFromEdge1.duplicate_around_axis(axis=Z, angle=(360/8) deg, total=8, attached)
  strip3_1_ObjectFromEdge1.duplicate_around_axis(axis=Z, angle=(360/8) deg, total=8, attached)
  strip4_1_ObjectFromEdge1.duplicate_around_axis(axis=Z, angle=(360/8) deg, total=8, attached)
  strip1_2_ObjectFromEdge1.duplicate_around_axis(axis=Z, angle=(360/8) deg, total=8, attached)
  strip2_2_ObjectFromEdge1.duplicate_around_axis(axis=Z, angle=(360/8) deg, total=8, attached)
  strip3_2_ObjectFromEdge1.duplicate_around_axis(axis=Z, angle=(360/8) deg, total=8, attached)
  strip4_2_ObjectFromEdge1.duplicate_around_axis(axis=Z, angle=(360/8) deg, total=8, attached)
  Source1_1_Separate7, Source1_1_Separate1..Source1_1_Separate6 = Source1_1.separate_bodies()
  Source2_1_Separate7, Source2_1_Separate1..Source2_1_Separate6 = Source2_1.separate_bodies()
  Source3_1_Separate7, Source3_1_Separate1..Source3_1_Separate6 = Source3_1.separate_bodies()
  Source4_1_Separate7, Source4_1_Separate1..Source4_1_Separate6 = Source4_1.separate_bodies()
  Polyline3_Separate7, Polyline3_Separate1..Polyline3_Separate6 = Polyline3.separate_bodies()
  Polyline2_Separate7, Polyline2_Separate1..Polyline2_Separate6 = Polyline2.separate_bodies()
  Polyline4_1_Separate7, Polyline4_1_Separate1..Polyline4_1_Separate6 = Polyline4_1.separate_bodies()
  Polyline7_1_Separate7, Polyline7_1_Separate1..Polyline7_1_Separate6 = Polyline7_1.separate_bodies()
  Polyline8_1_Separate7, Polyline8_1_Separate1..Polyline8_1_Separate6 = Polyline8_1.separate_bodies()
  Polyline6_1_Separate7, Polyline6_1_Separate1..Polyline6_1_Separate6 = Polyline6_1.separate_bodies()
  Source1_2_Separate7, Source1_2_Separate1..Source1_2_Separate6 = Source1_2.separate_bodies()
  Source2_2_Separate7, Source2_2_Separate1..Source2_2_Separate6 = Source2_2.separate_bodies()
  Source3_2_Separate7, Source3_2_Separate1..Source3_2_Separate6 = Source3_2.separate_bodies()
  Source4_2_Separate7, Source4_2_Separate1..Source4_2_Separate6 = Source4_2.separate_bodies()
  strip1_1_Separate7, strip1_1_Separate1..strip1_1_Separate6 = strip1_1.separate_bodies()
  Source1_1.separate_bodies()
  Source2_1.separate_bodies()
  Source3_1.separate_bodies()
  Source4_1.separate_bodies()
  Source4_2.separate_bodies()
  Source3_2.separate_bodies()
  Source2_2.separate_bodies()
  Source1_2.separate_bodies()
  strip4_1_Separate7, strip4_1_Separate1..strip4_1_Separate6 = strip4_1.separate_bodies()
  strip4_2_Separate7, strip4_2_Separate1..strip4_2_Separate6 = strip4_2.separate_bodies()
  strip3_1_Separate7, strip3_1_Separate1..strip3_1_Separate6 = strip3_1.separate_bodies()
  strip3_2_Separate7, strip3_2_Separate1..strip3_2_Separate6 = strip3_2.separate_bodies()
  strip2_1_Separate7, strip2_1_Separate1..strip2_1_Separate6 = strip2_1.separate_bodies()
  strip2_2_Separate7, strip2_2_Separate1..strip2_2_Separate6 = strip2_2.separate_bodies()
  strip1_1.separate_bodies()
  strip1_2_Separate7, strip1_2_Separate1..strip1_2_Separate6 = strip1_2.separate_bodies()
  Polyline2.separate_bodies()
  Polyline3.separate_bodies()
  Polyline4_1.separate_bodies()
  Polyline6_1.separate_bodies()
  Polyline7_1.separate_bodies()
  Polyline8_1.separate_bodies()
  strip1_1_ObjectFromEdge1_Separate7, strip1_1_ObjectFromEdge1_Separate1..strip1_1_ObjectFromEdge1_Separate6 = strip1_1_ObjectFromEdge1.separate_bodies()
  strip2_1_ObjectFromEdge1_Separate7, strip2_1_ObjectFromEdge1_Separate1..strip2_1_ObjectFromEdge1_Separate6 = strip2_1_ObjectFromEdge1.separate_bodies()
  strip3_1_ObjectFromEdge1_Separate7, strip3_1_ObjectFromEdge1_Separate1..strip3_1_ObjectFromEdge1_Separate6 = strip3_1_ObjectFromEdge1.separate_bodies()
  strip4_1_ObjectFromEdge1_Separate7, strip4_1_ObjectFromEdge1_Separate1..strip4_1_ObjectFromEdge1_Separate6 = strip4_1_ObjectFromEdge1.separate_bodies()
  strip1_2_ObjectFromEdge1_Separate7, strip1_2_ObjectFromEdge1_Separate1..strip1_2_ObjectFromEdge1_Separate6 = strip1_2_ObjectFromEdge1.separate_bodies()
  strip2_2_ObjectFromEdge1_Separate7, strip2_2_ObjectFromEdge1_Separate1..strip2_2_ObjectFromEdge1_Separate6 = strip2_2_ObjectFromEdge1.separate_bodies()
  strip3_2_ObjectFromEdge1_Separate7, strip3_2_ObjectFromEdge1_Separate1..strip3_2_ObjectFromEdge1_Separate6 = strip3_2_ObjectFromEdge1.separate_bodies()
  strip4_2_ObjectFromEdge1_Separate7, strip4_2_ObjectFromEdge1_Separate1..strip4_2_ObjectFromEdge1_Separate6 = strip4_2_ObjectFromEdge1.separate_bodies()
  Source1_1_Separate1.separate_bodies()
  Source1_1_Separate2.separate_bodies()
  Source1_1_Separate3.separate_bodies()
  Source1_1_Separate4.separate_bodies()
  Source1_1_Separate5.separate_bodies()
  Source1_1_Separate6.separate_bodies()
  Source1_1_Separate7.separate_bodies()
  Source2_1_Separate1.separate_bodies()
  Source2_1_Separate2.separate_bodies()
  Source2_1_Separate3.separate_bodies()
  Source2_1_Separate4.separate_bodies()
  Source2_1_Separate5.separate_bodies()
  Source2_1_Separate6.separate_bodies()
  Source2_1_Separate7.separate_bodies()
  Source3_1_Separate1.separate_bodies()
  Source3_1_Separate2.separate_bodies()
  Source3_1_Separate3.separate_bodies()
  Source3_1_Separate4.separate_bodies()
  Source3_1_Separate5.separate_bodies()
  Source3_1_Separate6.separate_bodies()
  Source3_1_Separate7.separate_bodies()
  Source4_1_Separate1.separate_bodies()
  Source4_1_Separate2.separate_bodies()
  Source4_1_Separate3.separate_bodies()
  Source4_1_Separate4.separate_bodies()
  Source4_1_Separate5.separate_bodies()
  Source4_1_Separate6.separate_bodies()
  Source4_1_Separate7.separate_bodies()
  Polyline3_Separate1.separate_bodies()
  Polyline3_Separate2.separate_bodies()
  Polyline3_Separate3.separate_bodies()
  Polyline3_Separate4.separate_bodies()
  Polyline3_Separate5.separate_bodies()
  Polyline3_Separate6.separate_bodies()
  Polyline3_Separate7.separate_bodies()
  Polyline2_Separate1.separate_bodies()
  Polyline2_Separate2.separate_bodies()
  Polyline2_Separate3.separate_bodies()
  Polyline2_Separate4.separate_bodies()
  Polyline2_Separate5.separate_bodies()
  Polyline2_Separate6.separate_bodies()
  Polyline2_Separate7.separate_bodies()
  Polyline4_1_Separate1.separate_bodies()
  Polyline4_1_Separate2.separate_bodies()
  Polyline4_1_Separate3.separate_bodies()
  Polyline4_1_Separate4.separate_bodies()
  Polyline4_1_Separate5.separate_bodies()
  Polyline4_1_Separate6.separate_bodies()
  Polyline4_1_Separate7.separate_bodies()
  Polyline7_1_Separate1.separate_bodies()
  Polyline7_1_Separate2.separate_bodies()
  Polyline7_1_Separate3.separate_bodies()
  Polyline7_1_Separate4.separate_bodies()
  Polyline7_1_Separate5.separate_bodies()
  Polyline7_1_Separate6.separate_bodies()
  Polyline7_1_Separate7.separate_bodies()
  Polyline8_1_Separate1.separate_bodies()
  Polyline8_1_Separate2.separate_bodies()
  Polyline8_1_Separate3.separate_bodies()
  Polyline8_1_Separate4.separate_bodies()
  Polyline8_1_Separate5.separate_bodies()
  Polyline8_1_Separate6.separate_bodies()
  Polyline8_1_Separate7.separate_bodies()
  Polyline6_1_Separate1.separate_bodies()
  Polyline6_1_Separate2.separate_bodies()
  Polyline6_1_Separate3.separate_bodies()
  Polyline6_1_Separate4.separate_bodies()
  Polyline6_1_Separate5.separate_bodies()
  Polyline6_1_Separate6.separate_bodies()
  Polyline6_1_Separate7.separate_bodies()
  Source1_2_Separate1.separate_bodies()
  Source1_2_Separate2.separate_bodies()
  Source1_2_Separate3.separate_bodies()
  Source1_2_Separate4.separate_bodies()
  Source1_2_Separate5.separate_bodies()
  Source1_2_Separate6.separate_bodies()
  Source1_2_Separate7.separate_bodies()
  Source2_2_Separate1.separate_bodies()
  Source2_2_Separate2.separate_bodies()
  Source2_2_Separate3.separate_bodies()
  Source2_2_Separate4.separate_bodies()
  Source2_2_Separate5.separate_bodies()
  Source2_2_Separate6.separate_bodies()
  Source2_2_Separate7.separate_bodies()
  Source3_2_Separate1.separate_bodies()
  Source3_2_Separate2.separate_bodies()
  Source3_2_Separate3.separate_bodies()
  Source3_2_Separate4.separate_bodies()
  Source3_2_Separate5.separate_bodies()
  Source3_2_Separate6.separate_bodies()
  Source3_2_Separate7.separate_bodies()
  Source4_2_Separate1.separate_bodies()
  Source4_2_Separate2.separate_bodies()
  Source4_2_Separate3.separate_bodies()
  Source4_2_Separate4.separate_bodies()
  Source4_2_Separate5.separate_bodies()
  Source4_2_Separate6.separate_bodies()
  Source4_2_Separate7.separate_bodies()
  strip1_1_Separate1.separate_bodies()
  strip1_1_Separate2.separate_bodies()
  strip1_1_Separate3.separate_bodies()
  strip1_1_Separate4.separate_bodies()
  strip1_1_Separate5.separate_bodies()
  strip1_1_Separate6.separate_bodies()
  strip1_1_Separate7.separate_bodies()
  Ch1CS1 [non-model] = polyline((77.904193mm, 119.31968mm, 86.5mm) (95.671816mm, 146.53294mm, 86.5mm))
  Ch1CS2 [non-model] = polyline((65.241206mm, 126.68794mm, 86.5mm) (80.120779mm, 155.58169mm, 86.5mm))
  Ch1CS3 [non-model] = polyline((43.449405mm, 135.7144mm, 86.5mm) (53.358918mm, 166.66681mm, 86.5mm))
  Ch1CS4 [non-model] = polyline((29.285174mm, 139.45834mm, 86.5mm) (35.964249mm, 171.26463mm, 86.5mm))
  Ch2CS1 [non-model] = polyline((139.45834mm, 29.285174mm, 86.5mm) (171.26463mm, 35.964249mm, 86.5mm))
  Ch2CS2 [non-model] = polyline((135.7144mm, 43.449405mm, 86.5mm) (166.66681mm, 53.358918mm, 86.5mm))
  Ch2CS3 [non-model] = polyline((126.68794mm, 65.241206mm, 86.5mm) (155.58169mm, 80.120779mm, 86.5mm))
  Ch2CS4 [non-model] = polyline((119.31968mm, 77.904193mm, 86.5mm) (146.53294mm, 95.671816mm, 86.5mm))
  Ch4CS1 [non-model] = polyline((29.285174mm, -139.45834mm, 86.5mm) (35.964249mm, -171.26463mm, 86.5mm))
  Ch4CS2 [non-model] = polyline((43.449405mm, -135.7144mm, 86.5mm) (53.358918mm, -166.66681mm, 86.5mm))
  Ch4CS3 [non-model] = polyline((65.241206mm, -126.68794mm, 86.5mm) (80.120779mm, -155.58169mm, 86.5mm))
  Ch4CS4 [non-model] = polyline((77.904193mm, -119.31968mm, 86.5mm) (95.671816mm, -146.53294mm, 86.5mm))
  Ch5CS1 [non-model] = polyline((-77.904193mm, -119.31968mm, 86.5mm) (-95.671816mm, -146.53294mm, 86.5mm))
  Ch5CS2 [non-model] = polyline((-65.241206mm, -126.68794mm, 86.5mm) (-80.120779mm, -155.58169mm, 86.5mm))
  Ch5CS3 [non-model] = polyline((-43.449405mm, -135.7144mm, 86.5mm) (-53.358918mm, -166.66681mm, 86.5mm))
  Ch5CS4 [non-model] = polyline((-29.285174mm, -139.45834mm, 86.5mm) (-35.964249mm, -171.26463mm, 86.5mm))
  Ch6CS1 [non-model] = polyline((-139.45834mm, -29.285174mm, 86.5mm) (-171.26463mm, -35.964249mm, 86.5mm))
  Ch6CS2 [non-model] = polyline((-135.7144mm, -43.449405mm, 86.5mm) (-166.66681mm, -53.358918mm, 86.5mm))
  Ch6CS3 [non-model] = polyline((-126.68794mm, -65.241206mm, 86.5mm) (-155.58169mm, -80.120779mm, 86.5mm))
  Ch6CS4 [non-model] = polyline((-119.31968mm, -77.904193mm, 86.5mm) (-146.53294mm, -95.671816mm, 86.5mm))
  Ch7CS1 [non-model] = polyline((-119.31968mm, 77.904193mm, 86.5mm) (-146.53294mm, 95.671816mm, 86.5mm))
  Ch7CS2 [non-model] = polyline((-126.68794mm, 65.241206mm, 86.5mm) (-155.58169mm, 80.120779mm, 86.5mm))
  Ch7CS3 [non-model] = polyline((-135.7144mm, 43.449405mm, 86.5mm) (-166.66681mm, 53.358918mm, 86.5mm))
  Ch7CS4 [non-model] = polyline((-139.45834mm, 29.285174mm, 86.5mm) (-171.26463mm, 35.964249mm, 86.5mm))
  Ch8CS1 [non-model] = polyline((-29.285174mm, 139.45834mm, 86.5mm) (-35.964249mm, 171.26463mm, 86.5mm))
  Ch8CS2 [non-model] = polyline((-43.449405mm, 135.7144mm, 86.5mm) (-53.358918mm, 166.66681mm, 86.5mm))
  Ch8CS3 [non-model] = polyline((-65.241206mm, 126.68794mm, 86.5mm) (-80.120779mm, 155.58169mm, 86.5mm))
  Ch8CS4 [non-model] = polyline((-77.904193mm, 119.31968mm, 86.5mm) (-95.671816mm, 146.53294mm, 86.5mm))
  Ch1CS5 [non-model] = polyline((73.768249mm, 121.92004mm, 80.5mm) (69.545599mm, 124.37709mm, 80.5mm))
  Ch1CS6 [non-model] = polyline((60.860128mm, 128.84989mm, 80.5mm) (48.076024mm, 134.14524mm, 80.5mm))
  Ch1CS7 [non-model] = polyline((38.771716mm, 137.12405mm, 80.5mm) (34.048455mm, 138.37251mm, 80.5mm))
  Ch2CS5 [non-model] = polyline((138.37251mm, 34.048455mm, 80.5mm) (137.12405mm, 38.771716mm, 80.5mm))
  Ch2CS6 [non-model] = polyline((134.14524mm, 48.076024mm, 80.5mm) (128.84989mm, 60.860128mm, 80.5mm))
  Ch2CS7 [non-model] = polyline((124.37709mm, 69.545599mm, 80.5mm) (121.92004mm, 73.768249mm, 80.5mm))
  Ch4CS5 [non-model] = polyline((34.048455mm, -138.37251mm, 80.5mm) (38.771716mm, -137.12405mm, 80.5mm))
  Ch4CS6 [non-model] = polyline((48.076024mm, -134.14524mm, 80.5mm) (60.860128mm, -128.84989mm, 80.5mm))
  Ch4CS7 [non-model] = polyline((69.545599mm, -124.37709mm, 80.5mm) (73.768249mm, -121.92004mm, 80.5mm))
  Ch5CS5 [non-model] = polyline((-73.768249mm, -121.92004mm, 80.5mm) (-69.545599mm, -124.37709mm, 80.5mm))
  Ch5CS6 [non-model] = polyline((-60.860128mm, -128.84989mm, 80.5mm) (-48.076024mm, -134.14524mm, 80.5mm))
  Ch5CS7 [non-model] = polyline((-38.771716mm, -137.12405mm, 80.5mm) (-34.048455mm, -138.37251mm, 80.5mm))
  Ch6CS5 [non-model] = polyline((-138.37251mm, -34.048455mm, 80.5mm) (-137.12405mm, -38.771716mm, 80.5mm))
  Ch6CS6 [non-model] = polyline((-134.14524mm, -48.076024mm, 80.5mm) (-128.84989mm, -60.860128mm, 80.5mm))
  Ch6CS7 [non-model] = polyline((-124.37709mm, -69.545599mm, 80.5mm) (-121.92004mm, -73.768249mm, 80.5mm))
  Ch7CS5 [non-model] = polyline((-121.92004mm, 73.768249mm, 80.5mm) (-124.37709mm, 69.545599mm, 80.5mm))
  Ch7CS6 [non-model] = polyline((-128.84989mm, 60.860128mm, 80.5mm) (-134.14524mm, 48.076024mm, 80.5mm))
  Ch7CS7 [non-model] = polyline((-137.12405mm, 38.771716mm, 80.5mm) (-138.37251mm, 34.048455mm, 80.5mm))
  Ch8CS5 [non-model] = polyline((-34.048455mm, 138.37251mm, 80.5mm) (-38.771716mm, 137.12405mm, 80.5mm))
  Ch8CS6 [non-model] = polyline((-48.076024mm, 134.14524mm, 80.5mm) (-60.860128mm, 128.84989mm, 80.5mm))
  Ch8CS7 [non-model] = polyline((-69.545599mm, 124.37709mm, 80.5mm) (-73.768249mm, 121.92004mm, 80.5mm))
  Ch1CS1_bottom [non-model] = polyline((95.671816mm, 146.53294mm, -86.5mm) (77.904193mm, 119.31968mm, -86.5mm))
  Ch1CS2_bottom [non-model] = polyline((80.120779mm, 155.58169mm, -86.5mm) (65.241206mm, 126.68794mm, -86.5mm))
  Ch1CS3_bottom [non-model] = polyline((53.358918mm, 166.66681mm, -86.5mm) (43.449405mm, 135.7144mm, -86.5mm))
  Ch1CS4_bottom [non-model] = polyline((35.964249mm, 171.26463mm, -86.5mm) (29.285174mm, 139.45834mm, -86.5mm))
  Ch1CS5_bottom [non-model] = polyline((73.768249mm, 121.92004mm, -80.5mm) (69.545599mm, 124.37709mm, -80.5mm))
  Ch1CS6_bottom [non-model] = polyline((60.860128mm, 128.84989mm, -80.5mm) (48.076024mm, 134.14524mm, -80.5mm))
  Ch1CS7_bottom [non-model] = polyline((38.771716mm, 137.12405mm, -80.5mm) (34.048455mm, 138.37251mm, -80.5mm))
  ch3cs1 [non-model] = polyline((146.53294mm, -95.671816mm, 86.5mm) (119.31968mm, -77.904193mm, 86.5mm))
  ch3cs2 [non-model] = polyline((155.58169mm, -80.120779mm, 86.5mm) (126.68794mm, -65.241206mm, 86.5mm))
  ch3cs3 [non-model] = polyline((135.7144mm, -43.449405mm, 86.5mm) (166.66681mm, -53.358918mm, 86.5mm))
  ch3cs4 [non-model] = polyline((139.45834mm, -29.285174mm, 86.5mm) (171.26463mm, -35.964249mm, 86.5mm))
  ch3cs5 [non-model] = polyline((121.92004mm, -73.768249mm, 80.5mm) (124.37709mm, -69.545599mm, 80.5mm))
  ch3cs6 [non-model] = polyline((128.84989mm, -60.860128mm, 80.5mm) (134.14524mm, -48.076024mm, 80.5mm))
  ch3cs7 [non-model] = polyline((137.12405mm, -38.771716mm, 80.5mm) (138.37251mm, -34.048455mm, 80.5mm))
boundaries and excitations:
  Rad1: Radiation Objects=Region
  FiniteCond1: Finite Conductivity Objects=[strip4_2_Separate6, strip4_2_Separate7, strip4_2_Separate5, strip4_2_Separate4, strip4_2_Separate3, strip4_2_Separate2, strip4_2_Separate1, strip4_2, strip4_1_Separate7, strip4_1_Separate6, strip4_1_Separate5, strip4_1_Separate4, strip4_1_Separate3, strip4_1_Separate2, strip4_1_Separate1, strip4_1, strip3_2_Separate7, strip3_2_Separate6, strip3_2_Separate5, strip3_2_Separate4, strip3_2_Separate3, strip3_2_Separate1, strip3_2_Separate2, strip3_2, strip3_1_Separate7, strip3_1_Separate6, strip3_1_Separate5, strip3_1_Separate3, strip3_1_Separate4, strip3_1_Separate2, strip3_1_Separate1, strip3_1, strip2_2_Separate7, strip2_2_Separate6, strip2_2_Separate5, strip2_2_Separate4, strip2_2_Separate3, strip2_2_Separate2, strip2_2_Separate1, strip2_2, strip2_1_Separate7, strip2_1_Separate6, strip2_1_Separate5, strip2_1_Separate4, strip2_1_Separate3, strip2_1_Separate2, strip2_1_Separate1, strip2_1, strip1_2_Separate7, strip1_2_Separate6, strip1_2_Separate5, strip1_2_Separate4, strip1_2_Separate3, strip1_2_Separate2, strip1_2_Separate1, strip1_2, strip1_1_Separate7, strip1_1_Separate6, strip1_1_Separate5, strip1_1_Separate4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] UseMaterial Material=copper IsInternal
  FiniteCond2: Finite Conductivity Objects=[Polyline2, Polyline2_Separate1..Polyline2_Separate7, Polyline3, Polyline3_Separate1..Polyline3_Separate7, Polyline4_1, Polyline4_1_Separate1..Polyline4_1_Separate7, Polyline6_1, Polyline6_1_Separate1..Polyline6_1_Separate7, Polyline7_1, Polyline7_1_Separate1..Polyline7_1_Separate7, Polyline8_1, Polyline8_1_Separate1..Polyline8_1_Separate7, Source1_1, Source1_1_Separate1..Source1_1_Separate7, Source1_2, Source1_2_Separate1..Source1_2_Separate7, Source2_1, Source2_1_Separate1..Source2_1_Separate7, Source2_2, Source2_2_Separate1..Source2_2_Separate7, Source3_1, Source3_1_Separate1..Source3_1_Separate7, Source3_2, Source3_2_Separate1..Source3_2_Separate7, Source4_1, Source4_1_Separate1..Source4_1_Separate7, Source4_2, Source4_2_Separate1..Source4_2_Separate7] UseMaterial Material=copper IsInternal
  Current1-1: Current Objects=Source1_1 Direction{(95.671816, 146.53294, 86.5) -> (77.904193, 119.31968, 86.5)}
  Current1-2: Current Objects=Source2_1 Direction{(80.120779, 155.58169, 86.5) -> (65.241206, 126.68794, 86.5)}
  Current1-3: Current Objects=Source3_1 Direction{(43.449405, 135.7144, 86.5) -> (53.358918, 166.66681, 86.5)}
  Current1-4: Current Objects=Source4_1 Direction{(29.285174, 139.45834, 86.5) -> (35.964249, 171.26463, 86.5)}
  Current1-5: Current Objects=Source1_2 Direction{(77.904193, 119.31968, -86.5) -> (95.671816, 146.53294, -86.5)}
  Current1-6: Current Objects=Source2_2 Direction{(65.241206, 126.68794, -86.5) -> (80.120779, 155.58169, -86.5)}
  Current1-7: Current Objects=Source3_2 Direction{(53.358918, 166.66681, -86.5) -> (43.449405, 135.7144, -86.5)}
  Current1-8: Current Objects=Source4_2 Direction{(35.964249, 171.26463, -86.5) -> (29.285174, 139.45834, -86.5)}
  Current1-9: Current Objects=Polyline7_1 Direction{(48.076024, 134.14524, -80.5) -> (60.860128, 128.84989, -80.5)}
  Current1-10: Current Objects=Polyline2 Direction{(73.768249, 121.92004, 80.5) -> (69.545599, 124.37709, 80.5)}
  Current1-11: Current Objects=Polyline3 Direction{(60.860128, 128.84989, 80.5) -> (48.076024, 134.14524, 80.5)}
  Current1-12: Current Objects=Polyline4_1 Direction{(38.771716, 137.12405, 80.5) -> (34.048455, 138.37251, 80.5)}
  Current1-13: Current Objects=Polyline8_1 Direction{(69.545599, 124.37709, -80.5) -> (73.768249, 121.92004, -80.5)}
  Current1-14: Current Objects=Polyline6_1 Direction{(34.048455, 138.37251, -80.5) -> (38.771716, 137.12405, -80.5)}
  Current2-1: Current Objects=Source1_1_Separate1 Direction{(171.26463, 35.964249, 86.5) -> (139.45834, 29.285174, 86.5)}
  Current2-2: Current Objects=Source2_1_Separate1 Direction{(166.66681, 53.358918, 86.5) -> (135.7144, 43.449405, 86.5)}
  Current2-3: Current Objects=Source3_1_Separate1 Direction{(126.68794, 65.241206, 86.5) -> (155.58169, 80.120779, 86.5)}
  Current2-4: Current Objects=Source4_1_Separate1 Direction{(119.31968, 77.904193, 86.5) -> (146.53294, 95.671816, 86.5)}
  Current2-5: Current Objects=Source1_2_Separate1 Direction{(139.45834, 29.285174, -86.5) -> (171.26463, 35.964249, -86.5)}
  Current2-6: Current Objects=Source2_2_Separate1 Direction{(135.7144, 43.449405, -86.5) -> (166.66681, 53.358918, -86.5)}
  Current2-7: Current Objects=Source3_2_Separate1 Direction{(155.58169, 80.120779, -86.5) -> (126.68794, 65.241206, -86.5)}
  Current2-8: Current Objects=Source4_2_Separate1 Direction{(146.53294, 95.671816, -86.5) -> (119.31968, 77.904193, -86.5)}
  Current2-9: Current Objects=Polyline7_1_Separate1 Direction{(128.84989, 60.860128, -80.5) -> (134.14524, 48.076024, -80.5)}
  Current2-10: Current Objects=Polyline2_Separate1 Direction{(138.37251, 34.048455, 80.5) -> (137.12405, 38.771716, 80.5)}
  Current2-11: Current Objects=Polyline3_Separate1 Direction{(134.14524, 48.076024, 80.5) -> (128.84989, 60.860128, 80.5)}
  Current2-12: Current Objects=Polyline4_1_Separate1 Direction{(124.37709, 69.545599, 80.5) -> (121.92004, 73.768249, 80.5)}
  Current2-13: Current Objects=Polyline8_1_Separate1 Direction{(137.12405, 38.771716, -80.5) -> (138.37251, 34.048455, -80.5)}
  Current2-14: Current Objects=Polyline6_1_Separate1 Direction{(121.92004, 73.768249, -80.5) -> (124.37709, 69.545599, -80.5)}
  Current3-1: Current Objects=Source1_1_Separate2 Direction{(146.53294, -95.671816, 86.5) -> (119.31968, -77.904193, 86.5)}
  Current3-2: Current Objects=Source2_1_Separate2 Direction{(155.58169, -80.120779, 86.5) -> (126.68794, -65.241206, 86.5)}
  Current3-3: Current Objects=Source3_1_Separate2 Direction{(135.7144, -43.449405, 86.5) -> (166.66681, -53.358918, 86.5)}
  Current3-4: Current Objects=Source4_1_Separate2 Direction{(139.45834, -29.285174, 86.5) -> (171.26463, -35.964249, 86.5)}
  Current3-9: Current Objects=Polyline7_1_Separate2 Direction{(134.14524, -48.076024, -80.5) -> (128.84989, -60.860128, -80.5)}
  Current3-10: Current Objects=Polyline2_Separate2 Direction{(121.92004, -73.768249, 80.5) -> (124.37709, -69.545599, 80.5)}
  Current3-11: Current Objects=Polyline3_Separate2 Direction{(128.84989, -60.860128, 80.5) -> (134.14524, -48.076024, 80.5)}
  Current3-12: Current Objects=Polyline4_1_Separate2 Direction{(137.12405, -38.771716, 80.5) -> (138.37251, -34.048455, 80.5)}
  Current3-13: Current Objects=Polyline8_1_Separate2 Direction{(124.37709, -69.545599, -80.5) -> (121.92004, -73.768249, -80.5)}
  Current3-14: Current Objects=Polyline6_1_Separate2 Direction{(138.37251, -34.048455, -80.5) -> (137.12405, -38.771716, -80.5)}
  Current4-1: Current Objects=Source1_1_Separate3 Direction{(35.964249, -171.26463, 86.5) -> (29.285174, -139.45834, 86.5)}
  Current4-2: Current Objects=Source2_1_Separate3 Direction{(53.358918, -166.66681, 86.5) -> (43.449405, -135.7144, 86.5)}
  Current4-3: Current Objects=Source3_1_Separate3 Direction{(65.241206, -126.68794, 86.5) -> (80.120779, -155.58169, 86.5)}
  Current4-4: Current Objects=Source4_1_Separate3 Direction{(77.904193, -119.31968, 86.5) -> (95.671816, -146.53294, 86.5)}
  Current4-5: Current Objects=Source1_2_Separate3 Direction{(29.285174, -139.45834, -86.5) -> (35.964249, -171.26463, -86.5)}
  Current4-6: Current Objects=Source2_2_Separate3 Direction{(43.449405, -135.7144, -86.5) -> (53.358918, -166.66681, -86.5)}
  Current4-7: Current Objects=Source3_2_Separate3 Direction{(80.120779, -155.58169, -86.5) -> (65.241206, -126.68794, -86.5)}
  Current4-8: Current Objects=Source4_2_Separate3 Direction{(95.671816, -146.53294, -86.5) -> (77.904193, -119.31968, -86.5)}
  Current4-9: Current Objects=Polyline7_1_Separate3 Direction{(60.860128, -128.84989, -80.5) -> (48.076024, -134.14524, -80.5)}
  Current4-10: Current Objects=Polyline2_Separate3 Direction{(34.048455, -138.37251, 80.5) -> (38.771716, -137.12405, 80.5)}
  Current4-11: Current Objects=Polyline3_Separate3 Direction{(48.076024, -134.14524, 80.5) -> (60.860128, -128.84989, 80.5)}
  Current4-12: Current Objects=Polyline4_1_Separate3 Direction{(69.545599, -124.37709, 80.5) -> (73.768249, -121.92004, 80.5)}
  Current4-13: Current Objects=Polyline8_1_Separate3 Direction{(38.771716, -137.12405, -80.5) -> (34.048455, -138.37251, -80.5)}
  Current4-14: Current Objects=Polyline6_1_Separate3 Direction{(73.768249, -121.92004, -80.5) -> (69.545599, -124.37709, -80.5)}
  Current5-1: Current Objects=Source1_1_Separate4 Direction{(-95.671816, -146.53294, 86.5) -> (-77.904193, -119.31968, 86.5)}
  Current5-2: Current Objects=Source2_1_Separate4 Direction{(-80.120779, -155.58169, 86.5) -> (-65.241206, -126.68794, 86.5)}
  Current5-3: Current Objects=Source3_1_Separate4 Direction{(-43.449405, -135.7144, 86.5) -> (-53.358918, -166.66681, 86.5)}
  Current5-4: Current Objects=Source4_1_Separate4 Direction{(-29.285174, -139.45834, 86.5) -> (-35.964249, -171.26463, 86.5)}
  Current5-5: Current Objects=Source1_2_Separate4 Direction{(-77.904193, -119.31968, -86.5) -> (-95.671816, -146.53294, -86.5)}
  Current5-6: Current Objects=Source2_2_Separate4 Direction{(-65.241206, -126.68794, -86.5) -> (-80.120779, -155.58169, -86.5)}
  Current5-7: Current Objects=Source3_2_Separate4 Direction{(-53.358918, -166.66681, -86.5) -> (-43.449405, -135.7144, -86.5)}
  Current5-8: Current Objects=Source4_2_Separate4 Direction{(-35.964249, -171.26463, -86.5) -> (-29.285174, -139.45834, -86.5)}
  Current5-9: Current Objects=Polyline7_1_Separate4 Direction{(-48.076024, -134.14524, -80.5) -> (-60.860128, -128.84989, -80.5)}
  Current5-10: Current Objects=Polyline2_Separate4 Direction{(-73.768249, -121.92004, 80.5) -> (-69.545599, -124.37709, 80.5)}
  Current5-11: Current Objects=Polyline3_Separate4 Direction{(-60.860128, -128.84989, 80.5) -> (-48.076024, -134.14524, 80.5)}
  Current5-12: Current Objects=Polyline4_1_Separate4 Direction{(-38.771716, -137.12405, 80.5) -> (-34.048455, -138.37251, 80.5)}
  Current5-13: Current Objects=Polyline8_1_Separate4 Direction{(-69.545599, -124.37709, -80.5) -> (-73.768249, -121.92004, -80.5)}
  Current5-14: Current Objects=Polyline6_1_Separate4 Direction{(-34.048455, -138.37251, -80.5) -> (-38.771716, -137.12405, -80.5)}
  Current3-5: Current Objects=Source1_2_Separate2 Direction{(119.31968, -77.904193, -86.5) -> (146.53294, -95.671816, -86.5)}
  Current3-6: Current Objects=Source2_2_Separate2 Direction{(126.68794, -65.241206, -86.5) -> (155.58169, -80.120779, -86.5)}
  Current3-7: Current Objects=Source3_2_Separate2 Direction{(166.66681, -53.358918, -86.5) -> (135.7144, -43.449405, -86.5)}
  Current3-8: Current Objects=Source4_2_Separate2 Direction{(171.26463, -35.964249, -86.5) -> (139.45834, -29.285174, -86.5)}
  Current6-1: Current Objects=Source1_1_Separate5 Direction{(-171.26463, -35.964249, 86.5) -> (-139.45834, -29.285174, 86.5)}
  Current6-2: Current Objects=Source2_1_Separate5 Direction{(-166.66681, -53.358918, 86.5) -> (-135.7144, -43.449405, 86.5)}
  Current6-3: Current Objects=Source3_1_Separate5 Direction{(-126.68794, -65.241206, 86.5) -> (-155.58169, -80.120779, 86.5)}
  Current6-4: Current Objects=Source4_1_Separate5 Direction{(-119.31968, -77.904193, 86.5) -> (-146.53294, -95.671816, 86.5)}
  Current6-5: Current Objects=Source1_2_Separate5 Direction{(-139.45834, -29.285174, -86.5) -> (-171.26463, -35.964249, -86.5)}
  Current6-6: Current Objects=Source2_2_Separate5 Direction{(-135.7144, -43.449405, -86.5) -> (-166.66681, -53.358918, -86.5)}
  Current6-7: Current Objects=Source3_2_Separate5 Direction{(-155.58169, -80.120779, -86.5) -> (-126.68794, -65.241206, -86.5)}
  Current6-8: Current Objects=Source4_2_Separate5 Direction{(-146.53294, -95.671816, -86.5) -> (-119.31968, -77.904193, -86.5)}
  Current6-9: Current Objects=Polyline7_1_Separate5 Direction{(-128.84989, -60.860128, -80.5) -> (-134.14524, -48.076024, -80.5)}
  Current6-10: Current Objects=Polyline2_Separate5 Direction{(-138.37251, -34.048455, 80.5) -> (-137.12405, -38.771716, 80.5)}
  Current6-11: Current Objects=Polyline3_Separate5 Direction{(-134.14524, -48.076024, 80.5) -> (-128.84989, -60.860128, 80.5)}
  Current6-12: Current Objects=Polyline4_1_Separate5 Direction{(-124.37709, -69.545599, 80.5) -> (-121.92004, -73.768249, 80.5)}
  Current6-13: Current Objects=Polyline8_1_Separate5 Direction{(-137.12405, -38.771716, -80.5) -> (-138.37251, -34.048455, -80.5)}
  Current6-14: Current Objects=Polyline6_1_Separate5 Direction{(-121.92004, -73.768249, -80.5) -> (-124.37709, -69.545599, -80.5)}
  Current7-1: Current Objects=Source1_1_Separate6 Direction{(-146.53294, 95.671816, 86.5) -> (-119.31968, 77.904193, 86.5)}
  Current7-2: Current Objects=Source2_1_Separate6 Direction{(-155.58169, 80.120779, 86.5) -> (-126.68794, 65.241206, 86.5)}
  Current7-3: Current Objects=Source3_1_Separate6 Direction{(-135.7144, 43.449405, 86.5) -> (-166.66681, 53.358918, 86.5)}
  Current7-4: Current Objects=Source4_1_Separate6 Direction{(-139.45834, 29.285174, 86.5) -> (-171.26463, 35.964249, 86.5)}
  Current7-5: Current Objects=Source1_2_Separate6 Direction{(-119.31968, 77.904193, -86.5) -> (-146.53294, 95.671816, -86.5)}
  Current7-6: Current Objects=Source2_2_Separate6 Direction{(-126.68794, 65.241206, -86.5) -> (-155.58169, 80.120779, -86.5)}
  Current7-7: Current Objects=Source3_2_Separate6 Direction{(-166.66681, 53.358918, -86.5) -> (-135.7144, 43.449405, -86.5)}
  Current7-8: Current Objects=Source4_2_Separate6 Direction{(-171.26463, 35.964249, -86.5) -> (-139.45834, 29.285174, -86.5)}
  Current7-9: Current Objects=Polyline7_1_Separate6 Direction{(-134.14524, 48.076024, -80.5) -> (-128.84989, 60.860128, -80.5)}
  Current7-10: Current Objects=Polyline2_Separate6 Direction{(-121.92004, 73.768249, 80.5) -> (-124.37709, 69.545599, 80.5)}
  Current7-11: Current Objects=Polyline3_Separate6 Direction{(-128.84989, 60.860128, 80.5) -> (-134.14524, 48.076024, 80.5)}
  Current7-12: Current Objects=Polyline4_1_Separate6 Direction{(-137.12405, 38.771716, 80.5) -> (-138.37251, 34.048455, 80.5)}
  Current7-13: Current Objects=Polyline8_1_Separate6 Direction{(-124.37709, 69.545599, -80.5) -> (-121.92004, 73.768249, -80.5)}
  Current7-14: Current Objects=Polyline6_1_Separate6 Direction{(-138.37251, 34.048455, -80.5) -> (-137.12405, 38.771716, -80.5)}
  Current8-1: Current Objects=Source1_1_Separate7 Direction{(-35.964249, 171.26463, 86.5) -> (-29.285174, 139.45834, 86.5)}
  Current8-2: Current Objects=Source2_1_Separate7 Direction{(-53.358918, 166.66681, 86.5) -> (-43.449405, 135.7144, 86.5)}
  Current8-3: Current Objects=Source3_1_Separate7 Direction{(-65.241206, 126.68794, 86.5) -> (-80.120779, 155.58169, 86.5)}
  Current8-4: Current Objects=Source4_1_Separate7 Direction{(-77.904193, 119.31968, 86.5) -> (-95.671816, 146.53294, 86.5)}
  Current8-5: Current Objects=Source1_2_Separate7 Direction{(-29.285174, 139.45834, -86.5) -> (-35.964249, 171.26463, -86.5)}
  Current8-6: Current Objects=Source2_2_Separate7 Direction{(-43.449405, 135.7144, -86.5) -> (-53.358918, 166.66681, -86.5)}
  Current8-7: Current Objects=Source3_2_Separate7 Direction{(-80.120779, 155.58169, -86.5) -> (-65.241206, 126.68794, -86.5)}
  Current8-8: Current Objects=Source4_2_Separate7 Direction{(-95.671816, 146.53294, -86.5) -> (-77.904193, 119.31968, -86.5)}
  Current8-9: Current Objects=Polyline7_1_Separate7 Direction{(-60.860128, 128.84989, -80.5) -> (-48.076024, 134.14524, -80.5)}
  Current8-10: Current Objects=Polyline2_Separate7 Direction{(-34.048455, 138.37251, 80.5) -> (-38.771716, 137.12405, 80.5)}
  Current8-11: Current Objects=Polyline3_Separate7 Direction{(-48.076024, 134.14524, 80.5) -> (-60.860128, 128.84989, 80.5)}
  Current8-12: Current Objects=Polyline4_1_Separate7 Direction{(-69.545599, 124.37709, 80.5) -> (-73.768249, 121.92004, 80.5)}
  Current8-13: Current Objects=Polyline8_1_Separate7 Direction{(-38.771716, 137.12405, -80.5) -> (-34.048455, 138.37251, -80.5)}
  Current8-14: Current Objects=Polyline6_1_Separate7 Direction{(-73.768249, 121.92004, -80.5) -> (-69.545599, 124.37709, -80.5)}
mesh:
  RFCOIL: LengthBased Objects=[strip1_1_Separate1..strip1_1_Separate7, strip1_2, strip1_2_Separate1..strip1_2_Separate7, strip2_1, strip2_1_Separate1..strip2_1_Separate7, strip2_2, strip2_2_Separate1..strip2_2_Separate7, strip3_1, strip3_1_Separate1..strip3_1_Separate7, strip3_2, strip3_2_Separate1..strip3_2_Separate7, strip4_1, strip4_1_Separate1..strip4_1_Separate7, strip4_2, strip4_2_Separate1..strip4_2_Separate7, strip1_1] MaxLength=5mm
  region: LengthBased RefineInside Objects=Region MaxLength=50mm
  phantom: LengthBased RefineInside Objects=phantom1 MaxLength=10mm
setups:
  Setup1: HfssDriven Frequency=298MHz MaxDeltaE=0.02 MaximumPasses=12 MinimumPasses=1 MinimumConvergedPasses=1 PercentRefinement=20 BasisOrder=1 DrivenSolverType="Direct Solver"
    sweep Sweep: 298MHz to 298MHz step 0.18MHz; Type=Discrete SaveFields
source amplitudes:
  Current1-1:1, Current1-2:1, Current1-3:1, Current1-4:1: UM1 UP1+PI1
  Current1-5:1, Current1-6:1, Current1-7:1, Current1-8:1: LM1 LP1+PI1
  Current1-9:1, Current1-10:1, Current1-11:1, Current1-12:1, Current1-13:1, Current1-14:1: MM1 MP1+PI1
  Current2-1:1, Current2-2:1, Current2-3:1, Current2-4:1: UM2 UP2+PI2
  Current2-5:1, Current2-6:1, Current2-7:1, Current2-8:1: LM2 LP2+PI2
  Current2-9:1, Current2-10:1, Current2-11:1, Current2-12:1, Current2-13:1, Current2-14:1: MM2 MP2+PI2
  Current3-1:1, Current3-2:1, Current3-3:1, Current3-4:1: UM3 UP3+PI3
  Current3-9:1, Current3-10:1, Current3-11:1, Current3-12:1, Current3-13:1, Current3-14:1: MM3 MP3+PI3
  Current4-1:1, Current4-2:1, Current4-3:1, Current4-4:1: UM4 UP4+PI4
  Current4-5:1, Current4-6:1, Current4-7:1, Current4-8:1: LM4 LP4+PI4
  Current4-9:1, Current4-10:1, Current4-11:1, Current4-12:1, Current4-13:1, Current4-14:1: MM4 MP4+PI4
  Current5-1:1, Current5-2:1, Current5-3:1, Current5-4:1: UM5 UP5+PI5
  Current5-5:1, Current5-6:1, Current5-7:1, Current5-8:1: LM5 LP5+PI5
  Current5-9:1, Current5-10:1, Current5-11:1, Current5-12:1, Current5-13:1, Current5-14:1: MM5 MP5+PI5
  Current3-5:1, Current3-6:1, Current3-7:1, Current3-8:1: LM3 LP3+PI3
  Current6-1:1, Current6-2:1, Current6-3:1, Current6-4:1: UM6 UP6+PI6
  Current6-5:1, Current6-6:1, Current6-7:1, Current6-8:1: LM6 LP6+PI6
  Current6-9:1, Current6-10:1, Current6-11:1, Current6-12:1, Current6-13:1, Current6-14:1: MM6 MP6+PI6
  Current7-1:1, Current7-2:1, Current7-3:1, Current7-4:1: UM7 UP7+PI7
  Current7-5:1, Current7-6:1, Current7-7:1, Current7-8:1: LM7 LP7+PI7
  Current7-9:1, Current7-10:1, Current7-11:1, Current7-12:1, Current7-13:1, Current7-14:1: MM7 MP7+PI7
  Current8-1:1, Current8-2:1, Current8-3:1, Current8-4:1: UM8 UP8+PI8
  Current8-5:1, Current8-6:1, Current8-7:1, Current8-8:1: LM8 LP8+PI8
  Current8-9:1, Current8-10:1, Current8-11:1, Current8-12:1, Current8-13:1, Current8-14:1: MM8 MP8+PI8
output variables:
  BrealX = H
field calculator expressions:
  CmplxMag_B1P = <Hx,Hy,Hz> | ScalarX | <Hx,Hy,Hz> | ScalarY | Complex_Constant(0, 1) | * | + | Complex_Constant(0.5, 0) | * | CmplxMag | 1.25664e-06 | *
  P = Fundamental_Quantity(0) | Mag | 2 | Pow | 0.5 | * | EnterVolume(phantom1) | VolumeValue | Integrate
  B1E = CmplxMag_B1P | P | Sqrt | /
  B1PP = CmplxMag_B1P | P | /
  B = <Hx,Hy,Hz> | Smooth | 1.25663706143592e-06 | *
  BimagX = B | Imag | ScalarX
  BimagY = B | Imag | ScalarY
  BimagZ = B | Imag | ScalarZ
  BrealX = B | Real | ScalarX
  BrealY = B | Real | ScalarY
  BrealZ = B | Real | ScalarZ
  bm = B | Mag
  Jszr = Fundamental_Quantity(1) | ScalarZ | Real
  Jszi = Fundamental_Quantity(1) | ScalarZ | Imag
  strp11 = Jszi | EnterLine(strip1_1_ObjectFromEdge1) | LineValue | Integrate | CmplxI | Jszr | EnterLine(strip1_1_ObjectFromEdge1) | LineValue | Integrate | CmplxR | +
  strp12 = Jszi | EnterLine(strip1_2_ObjectFromEdge1) | LineValue | Integrate | CmplxI | Jszr | EnterLine(strip1_2_ObjectFromEdge1) | LineValue | Integrate | CmplxR | +
  strp21 = Jszi | EnterLine(strip2_1_ObjectFromEdge1) | LineValue | Integrate | CmplxI | Jszr | EnterLine(strip2_1_ObjectFromEdge1) | LineValue | Integrate | CmplxR | +
  strp22 = Jszi | EnterLine(strip2_2_ObjectFromEdge1) | LineValue | Integrate | CmplxI | Jszr | EnterLine(strip2_2_ObjectFromEdge1) | LineValue | Integrate | CmplxR | +
  strp31 = Jszi | EnterLine(strip3_1_ObjectFromEdge1) | LineValue | Integrate | CmplxI | Jszr | EnterLine(strip3_1_ObjectFromEdge1) | LineValue | Integrate | CmplxR | +
  strp32 = Jszi | EnterLine(strip3_2_ObjectFromEdge1) | LineValue | Integrate | CmplxI | Jszr | EnterLine(strip3_2_ObjectFromEdge1) | LineValue | Integrate | CmplxR | +
  strp41 = Jszi | EnterLine(strip4_1_ObjectFromEdge1) | LineValue | Integrate | CmplxI | Jszr | EnterLine(strip4_1_ObjectFromEdge1) | LineValue | Integrate | CmplxR | +
  strp42 = Jszi | EnterLine(strip4_2_ObjectFromEdge1) | LineValue | Integrate | CmplxI | Jszr | EnterLine(strip4_2_ObjectFromEdge1) | LineValue | Integrate | CmplxR | +
  BF = <Hx,Hy,Hz> | ScalarY | 1.25663706143592e-06 | *
  BMag = B | Mag
  conductivity = Vector_Constant(1, 1, 1) | MaterialOp(Conductivity (cond)) | Smooth | Mag
field plots:
  BMag1: NamedExpr over Rectangle2.face on Setup1 : LastAdaptive at Freq=0.298GHz Phase=0deg

design NOVA_transmit_coil_model_14_current_sources (HFSS, HFSS Modal Network, model units mm)
options: Save_Adaptive_support_files
variables:
  rout = (350/2) mm
  h = 173mm
  rin = (285/2) mm
  sw = (360*stw)/(2*rout*pi) deg
  stw = 12mm
  htw = 6mm
  hw = (htw*360)/(rout*2*pi) deg
  htw2 = 17mm
  hw2 = (htw2*360)/(rout*2*pi) deg
  rp = (164/2) mm
  stt = 360deg
  aa = 0
  aaa = -5*(360/8) deg
  PI1 = 0deg
  PI2 = 0deg
  PI3 = 0deg
  PI4 = 0deg
  PI5 = 0deg
  PI6 = 0deg
  PI7 = 0deg
  PI8 = 0deg
  UM11 = 10mA
  UM12 = 0mA
  UM13 = 0mA
  UM14 = 0mA
  LM11 = 0mA
  LM12 = 0mA
  LM13 = 0mA
  LM14 = 0mA
  LM16 = 0mA
  UM15 = 0mA
  UM16 = 0mA
  UM17 = 0mA
  LM15 = 0mA
  LM17 = 0mA
  UM21 = 0mA
  UM22 = 0mA
  UM23 = 0mA
  UM24 = 0mA
  LM21 = 0mA
  LM22 = 0mA
  LM23 = 0mA
  LM24 = 0mA
  LM26 = 0mA
  UM25 = 0mA
  UM26 = 0mA
  UM27 = 0mA
  LM25 = 0mA
  LM27 = 0mA
  UM31 = 0mA
  UM32 = 0mA
  UM33 = 0mA
  UM34 = 0mA
  LM36 = 0mA
  UM35 = 0mA
  UM36 = 0mA
  UM37 = 0mA
  LM35 = 0mA
  LM37 = 0mA
  UM41 = 0mA
  UM42 = 0mA
  UM43 = 0mA
  UM44 = 0mA
  LM41 = 0mA
  LM42 = 0mA
  LM43 = 0mA
  LM44 = 0mA
  LM46 = 0mA
  UM45 = 0mA
  UM46 = 0mA
  UM47 = 0mA
  LM45 = 0mA
  LM47 = 0mA
  UM51 = 0mA
  UM52 = 0mA
  UM53 = 0mA
  UM54 = 0mA
  LM51 = 0mA
  LM52 = 0mA
  LM53 = 0mA
  LM54 = 0mA
  UM56 = 0mA
  UM55 = 0mA
  LM56 = 0mA
  UM57 = 0mA
  LM55 = 0mA
  LM57 = 0mA
  LM31 = 0mA
  LM32 = 0mA
  LM33 = 0mA
  LM34 = 0mA
  UM61 = 0mA
  UM62 = 0mA
  UM63 = 0mA
  UM64 = 0mA
  LM61 = 0mA
  LM62 = 0mA
  LM63 = 0mA
  LM64 = 0mA
  LM66 = 0mA
  UM65 = 0mA
  UM66 = 0mA
  UM67 = 0mA
  LM65 = 0mA
  LM67 = 0mA
  UM71 = 0mA
  UM72 = 0mA
  UM73 = 0mA
  UM74 = 0mA
  LM71 = 0mA
  LM72 = 0mA
  LM73 = 0mA
  LM74 = 0mA
  LM76 = 0mA
  UM75 = 0mA
  UM76 = 0mA
  UM77 = 0mA
  LM75 = 0mA
  LM77 = 0mA
  UM81 = 0mA
  UM82 = 0mA
  UM83 = 0mA
  UM84 = 0mA
  LM81 = 0mA
  LM82 = 0mA
  LM83 = 0mA
  LM84 = 0mA
  LM86 = 0mA
  UM85 = 0mA
  UM86 = 0mA
  UM87 = 0mA
  LM85 = 0mA
  LM87 = 0mA
  UP12 = 0deg
  UP13 = 0deg
  UP14 = 0deg
  LP11 = 0deg
  LP12 = 0deg
  LP13 = 0deg
  LP14 = 0deg
  LP16 = 0deg
  LP15 = 0deg
  UP15 = 0deg
  UP16 = 0deg
  UP17 = 0deg
  LP17 = 0deg
  UP21 = 0deg
  UP22 = 0deg
  UP23 = 0deg
  UP24 = 0deg
  LP21 = 0deg
  LP22 = 0deg
  LP23 = 0deg
  LP24 = 0deg
  LP26 = 0deg
  UP25 = 0deg
  UP26 = 0deg
  UP27 = 0deg
  LP25 = 0deg
  LP27 = 0deg
  UP31 = 0deg
  UP32 = 0deg
  UP33 = 0deg
  UP34 = 0deg
  LP36 = 0deg
  UP35 = 0deg
  UP36 = 0deg
  UP37 = 0deg
  LP35 = 0deg
  LP37 = 0deg
  UP41 = 0deg
  UP42 = 0deg
  UP43 = 0deg
  UP44 = 0deg
  LP41 = 0deg
  LP42 = 0deg
  LP43 = 0deg
  LP44 = 0deg
  LP46 = 0deg
  UP45 = 0deg
  UP46 = 0deg
  UP47 = 0deg
  LP45 = 0deg
  LP47 = 0deg
  UP51 = 0deg
  UP52 = 0deg
  UP53 = 0deg
  UP54 = 0deg
  LP51 = 0deg
  LP52 = 0deg
  LP53 = 0deg
  LP54 = 0deg
  LP56 = 0deg
  UP55 = 0deg
  UP56 = 0deg
  UP57 = 0deg
  LP55 = 0deg
  LP57 = 0deg
  LP31 = 0deg
  LP32 = 0deg
  LP33 = 0deg
  LP34 = 0deg
  UP61 = 0deg
  UP62 = 0deg
  UP63 = 0deg
  UP64 = 0deg
  LP61 = 0deg
  LP62 = 0deg
  LP63 = 0deg
  LP64 = 0deg
  LP66 = 0deg
  LP65 = 0deg
  UP66 = 0deg
  UP65 = 0deg
  UP67 = 0deg
  LP67 = 0deg
  UP71 = 0deg
  UP72 = 0deg
  UP73 = 0deg
  UP74 = 0deg
  LP71 = 0deg
  LP72 = 0deg
  LP73 = 0deg
  LP74 = 0deg
  LP76 = 0deg
  UP75 = 0deg
  UP76 = 0deg
  UP77 = 0deg
  LP75 = 0deg
  LP77 = 0deg
  UP81 = 0deg
  UP82 = 0deg
  UP83 = 0deg
  UP84 = 0deg
  LP81 = 0deg
  LP82 = 0deg
  LP83 = 0deg
  LP84 = 0deg
  LP86 = 0deg
  UP85 = 0deg
  UP86 = 0deg
  UP87 = 0deg
  LP85 = 0deg
  LP87 = 0deg
  UP11 = 0deg
geometry:
  Rectangle1 = rectangle(corner=(rout, 0mm, -h/2), z_size=h, x_size=-rout+rin)
  Rectangle1.sweep_around_axis(axis=Z, angle=sw)
  Rectangle1_1 = Rectangle1.duplicate_around_axis(axis=Z, angle=sw+hw, total=2)
  Rectangle1_2 = Rectangle1.duplicate_around_axis(axis=Z, angle=hw+hw2+2*sw, total=2)
  Rectangle1_1_1 = Rectangle1_1.duplicate_around_axis(axis=Z, angle=hw+hw2+2*sw, total=2)
  Source1_1 = object_from(Rectangle1.face(#43))
  Source2_1 = object_from(Rectangle1_1.face(1 of 6))
  Source3_1 = object_from(Rectangle1_2.face(1 of 6))
  Source4_1 = object_from(Rectangle1_1_1.face(1 of 6))
  Source4_2 = object_from(Rectangle1_1_1.face(3 of 6))
  Source3_2 = object_from(Rectangle1_2.face(3 of 6))
  Source2_2 = object_from(Rectangle1_1.face(3 of 6))
  Source1_2 = object_from(Rectangle1.face(#45))
  strip4_1, strip4_2 = object_from(Rectangle1_1_1.face(4 of 6, 2 of 6))
  Rectangle1_1_1.delete()
  strip3_1, strip3_2 = object_from(Rectangle1_2.face(4 of 6, 2 of 6))
  Rectangle1_2.delete()
  strip2_1, strip2_2 = object_from(Rectangle1_1.face(4 of 6, 2 of 6))
  Rectangle1_1.delete()
  strip1_1, strip1_2 = object_from(Rectangle1.face(#46, #44))
  Rectangle1.delete()
  phantom1 [Material250] = sphere(centre=(0mm, 0mm, 0mm), radius=rp)
  Rectangle2 = rectangle(corner=(-225mm, 225mm, 0mm), x_size=450mm, y_size=-450mm)
  [Source1_1, Source2_1, Source3_1, Source4_1, Source4_2, Source3_2, Source2_2, Source1_2, strip4_1, strip4_2, strip3_1, strip3_2, strip2_1, strip2_2, strip1_1, strip1_2].rotate(axis=Z, angle=-(2*sw+hw+hw2/2))
  [Source1_1, Source2_1, Source3_1, Source4_1, Source4_2, Source3_2, Source2_2, Source1_2, strip4_1, strip4_2, strip3_1, strip3_2, strip2_1, strip2_2, strip1_1, strip1_2].rotate(axis=Z, angle=((stt-8*(4*sw+hw2+2*hw))/16)+2*sw+hw+hw2/2)
  Polyline2 = polyline((137.12405mm, 38.771716mm, 86.5mm) (138.37251mm, 34.048455mm, 86.5mm))
  Polyline2_1 = Polyline2.duplicate_along_line(step=(0mm, 0mm, -stw), total=2)
  Polyline2.connect(Polyline2_1)
  Polyline3 = polyline((128.84989mm, 60.860128mm, 86.5mm) (134.14524mm, 48.076024mm, 86.5mm))
  Polyline3_1 = Polyline3.duplicate_along_line(step=(0mm, 0mm, -stw), total=2)
  Polyline3.connect(Polyline3_1)
  Polyline4 = polyline((124.37709mm, 69.545599mm, 86.5mm) (121.92004mm, 73.768249mm, 86.5mm))
  Polyline4_1 = Polyline4.duplicate_along_line(step=(0mm, 0mm, -stw), total=2)
  Polyline4_1.connect(Polyline4)
  Polyline6 = polyline((121.92004mm, 73.768249mm, -86.5mm) (124.37709mm, 69.545599mm, -86.5mm))
  Polyline6_1 = Polyline6.duplicate_along_line(step=(0mm, 0mm, stw), total=2)
  Polyline6_1.connect(Polyline6)
  Polyline7 = polyline((128.84989mm, 60.860128mm, -86.5mm) (134.14524mm, 48.076024mm, -86.5mm))
  Polyline7_1 = Polyline7.duplicate_along_line(step=(0mm, 0mm, stw), total=2)
  Polyline7_1.connect(Polyline7)
  Polyline8 = polyline((137.12405mm, 38.771716mm, -86.5mm) (138.37251mm, 34.048455mm, -86.5mm))
  Polyline8_1 = Polyline8.duplicate_along_line(step=(0mm, 0mm, stw), total=2)
  Polyline8_1.connect(Polyline8)
  Rectangle3 = rectangle(corner=(-225mm, 225mm, 0mm), x_size=450mm, y_size=-450mm)
  Rectangle2_119 [non-model] = Rectangle3.duplicate_around_axis(axis=X, angle=90deg, total=2)
  Rectangle3.delete()
  Rectangle2_119_1 [non-model] = Rectangle2_119.duplicate_around_axis(axis=Z, angle=90deg, total=2)
  strip1_1_ObjectFromEdge1 [non-model] = object_from(strip1_1.edge(2 of 4))
  strip1_1_ObjectFromEdge1.move(-5.6843419e-14mm, -7.1054274e-15mm, -86.5mm)
  strip2_1_ObjectFromEdge1 [non-model] = object_from(strip2_1.edge(2 of 4))
  strip2_1_ObjectFromEdge1.move(-2.8421709e-14mm, -2.1316282e-14mm, -86.5mm)
  strip3_1_ObjectFromEdge1 [non-model] = object_from(strip3_1.edge(2 of 4))
  strip3_1_ObjectFromEdge1.move(-2.8421709e-14mm, -1.4210855e-14mm, -86.5mm)
  strip4_1_ObjectFromEdge1 [non-model] = object_from(strip4_1.edge(2 of 4))
  strip4_1_ObjectFromEdge1.move(-2.8421709e-14mm, -1.4210855e-14mm, -86.5mm)
  strip1_2_ObjectFromEdge1 [non-model] = object_from(strip1_2.edge(4 of 4))
  strip1_2_ObjectFromEdge1.move(-2.8421709e-14mm, -1.4210855e-14mm, -86.5mm)
  strip2_2_ObjectFromEdge1 [non-model] = object_from(strip2_2.edge(4 of 4))
  strip2_2_ObjectFromEdge1.move(-2.8421709e-14mm, -2.1316282e-14mm, -86.5mm)
  strip3_2_ObjectFromEdge1 [non-model] = object_from(strip3_2.edge(4 of 4))
  strip3_2_ObjectFromEdge1.move(-2.8421709e-14mm, -2.8421709e-14mm, -86.5mm)
  strip4_2_ObjectFromEdge1 [non-model] = object_from(strip4_2.edge(4 of 4))
  strip4_2_ObjectFromEdge1.move(-2.8421709e-14mm, -2.8421709e-14mm, -86.5mm)
  [Source1_1, Source2_1, Source3_1, Source4_1, Source4_2, Source3_2, Source2_2, Source1_2, strip4_1, strip4_2, strip3_1, strip3_2, strip2_1, strip2_2, strip1_1, strip1_2, Polyline2, Polyline3, Polyline4_1, Polyline6_1, Polyline7_1, Polyline8_1, strip1_1_ObjectFromEdge1, strip2_1_ObjectFromEdge1, strip3_1_ObjectFromEdge1, strip4_1_ObjectFromEdge1, strip1_2_ObjectFromEdge1, strip2_2_ObjectFromEdge1, strip3_2_ObjectFromEdge1, strip4_2_ObjectFromEdge1].rotate(axis=Z, angle=-aa*(((stt-8*(4*sw+hw2+2*hw))/16)+2*sw+hw+hw2/2))
  [Source1_1, Source2_1, Source3_1, Source4_1, Source4_2, Source3_2, Source2_2, Source1_2, strip4_1, strip4_2, strip3_1, strip3_2, strip2_1, strip2_2, strip1_1, strip1_2, Polyline2, Polyline3, Polyline4_1, Polyline6_1, Polyline7_1, Polyline8_1, strip1_1_ObjectFromEdge1, strip2_1_ObjectFromEdge1, strip3_1_ObjectFromEdge1, strip4_1_ObjectFromEdge1, strip1_2_ObjectFromEdge1, strip2_2_ObjectFromEdge1, strip3_2_ObjectFromEdge1, strip4_2_ObjectFromEdge1].rotate(axis=Z, angle=(-360/8) deg)
  [Source1_1, Source2_1, Source3_1, Source4_1, Source4_2, Source3_2, Source2_2, Source1_2, strip4_1, strip4_2, strip3_1, strip3_2, strip2_1, strip2_2, strip1_1, strip1_2, Polyline2, Polyline3, Polyline4_1, Polyline6_1, Polyline7_1, Polyline8_1, strip1_1_ObjectFromEdge1, strip2_1_ObjectFromEdge1, strip3_1_ObjectFromEdge1, strip4_1_ObjectFromEdge1, strip1_2_ObjectFromEdge1, strip2_2_ObjectFromEdge1, strip3_2_ObjectFromEdge1, strip4_2_ObjectFromEdge1].rotate(axis=Z, angle=aaa)
  Region [vacuum] = region(absolute_offset=15cm on all sides)
  Source1_1.duplicate_around_axis(axis=Z, angle=(360/8) deg, total=8, attached)
  Source2_1.duplicate_around_axis(axis=Z, angle=(360/8) deg, total=8, attached)
  Source3_1.duplicate_around_axis(axis=Z, angle=(360/8) deg, total=8, attached)
  Source4_1.duplicate_around_axis(axis=Z, angle=(360/8) deg, total=8, attached)
  Source4_2.duplicate_around_axis(axis=Z, angle=(360/8) deg, total=8, attached)
  Source3_2.duplicate_around_axis(axis=Z, angle=(360/8) deg, total=8, attached)
  Source2_2.duplicate_around_axis(axis=Z, angle=(360/8) deg, total=8, attached)
  Source1_2.duplicate_around_axis(axis=Z, angle=(360/8) deg, total=8, attached)
  strip4_1.duplicate_around_axis(axis=Z, angle=(360/8) deg, total=8, attached)
  strip4_2.duplicate_around_axis(axis=Z, angle=(360/8) deg, total=8, attached)
  strip3_1.duplicate_around_axis(axis=Z, angle=(360/8) deg, total=8, attached)
  strip3_2.duplicate_around_axis(axis=Z, angle=(360/8) deg, total=8, attached)
  strip2_1.duplicate_around_axis(axis=Z, angle=(360/8) deg, total=8, attached)
  strip2_2.duplicate_around_axis(axis=Z, angle=(360/8) deg, total=8, attached)
  strip1_1.duplicate_around_axis(axis=Z, angle=(360/8) deg, total=8, attached)
  strip1_2.duplicate_around_axis(axis=Z, angle=(360/8) deg, total=8, attached)
  Polyline2.duplicate_around_axis(axis=Z, angle=(360/8) deg, total=8, attached)
  Polyline3.duplicate_around_axis(axis=Z, angle=(360/8) deg, total=8, attached)
  Polyline4_1.duplicate_around_axis(axis=Z, angle=(360/8) deg, total=8, attached)
  Polyline6_1.duplicate_around_axis(axis=Z, angle=(360/8) deg, total=8, attached)
  Polyline7_1.duplicate_around_axis(axis=Z, angle=(360/8) deg, total=8, attached)
  Polyline8_1.duplicate_around_axis(axis=Z, angle=(360/8) deg, total=8, attached)
  strip1_1_ObjectFromEdge1.duplicate_around_axis(axis=Z, angle=(360/8) deg, total=8, attached)
  strip2_1_ObjectFromEdge1.duplicate_around_axis(axis=Z, angle=(360/8) deg, total=8, attached)
  strip3_1_ObjectFromEdge1.duplicate_around_axis(axis=Z, angle=(360/8) deg, total=8, attached)
  strip4_1_ObjectFromEdge1.duplicate_around_axis(axis=Z, angle=(360/8) deg, total=8, attached)
  strip1_2_ObjectFromEdge1.duplicate_around_axis(axis=Z, angle=(360/8) deg, total=8, attached)
  strip2_2_ObjectFromEdge1.duplicate_around_axis(axis=Z, angle=(360/8) deg, total=8, attached)
  strip3_2_ObjectFromEdge1.duplicate_around_axis(axis=Z, angle=(360/8) deg, total=8, attached)
  strip4_2_ObjectFromEdge1.duplicate_around_axis(axis=Z, angle=(360/8) deg, total=8, attached)
  Source1_1_Separate7, Source1_1_Separate1..Source1_1_Separate6 = Source1_1.separate_bodies()
  Source2_1_Separate7, Source2_1_Separate1..Source2_1_Separate6 = Source2_1.separate_bodies()
  Source3_1_Separate7, Source3_1_Separate1..Source3_1_Separate6 = Source3_1.separate_bodies()
  Source4_1_Separate7, Source4_1_Separate1..Source4_1_Separate6 = Source4_1.separate_bodies()
  Polyline3_Separate7, Polyline3_Separate1..Polyline3_Separate6 = Polyline3.separate_bodies()
  Polyline2_Separate7, Polyline2_Separate1..Polyline2_Separate6 = Polyline2.separate_bodies()
  Polyline4_1_Separate7, Polyline4_1_Separate1..Polyline4_1_Separate6 = Polyline4_1.separate_bodies()
  Polyline7_1_Separate7, Polyline7_1_Separate1..Polyline7_1_Separate6 = Polyline7_1.separate_bodies()
  Polyline8_1_Separate7, Polyline8_1_Separate1..Polyline8_1_Separate6 = Polyline8_1.separate_bodies()
  Polyline6_1_Separate7, Polyline6_1_Separate1..Polyline6_1_Separate6 = Polyline6_1.separate_bodies()
  Source1_2_Separate7, Source1_2_Separate1..Source1_2_Separate6 = Source1_2.separate_bodies()
  Source2_2_Separate7, Source2_2_Separate1..Source2_2_Separate6 = Source2_2.separate_bodies()
  Source3_2_Separate7, Source3_2_Separate1..Source3_2_Separate6 = Source3_2.separate_bodies()
  Source4_2_Separate7, Source4_2_Separate1..Source4_2_Separate6 = Source4_2.separate_bodies()
  strip1_1_Separate7, strip1_1_Separate1..strip1_1_Separate6 = strip1_1.separate_bodies()
  Source1_1.separate_bodies()
  Source2_1.separate_bodies()
  Source3_1.separate_bodies()
  Source4_1.separate_bodies()
  Source4_2.separate_bodies()
  Source3_2.separate_bodies()
  Source2_2.separate_bodies()
  Source1_2.separate_bodies()
  strip4_1_Separate7, strip4_1_Separate1..strip4_1_Separate6 = strip4_1.separate_bodies()
  strip4_2_Separate7, strip4_2_Separate1..strip4_2_Separate6 = strip4_2.separate_bodies()
  strip3_1_Separate7, strip3_1_Separate1..strip3_1_Separate6 = strip3_1.separate_bodies()
  strip3_2_Separate7, strip3_2_Separate1..strip3_2_Separate6 = strip3_2.separate_bodies()
  strip2_1_Separate7, strip2_1_Separate1..strip2_1_Separate6 = strip2_1.separate_bodies()
  strip2_2_Separate7, strip2_2_Separate1..strip2_2_Separate6 = strip2_2.separate_bodies()
  strip1_1.separate_bodies()
  strip1_2_Separate7, strip1_2_Separate1..strip1_2_Separate6 = strip1_2.separate_bodies()
  Polyline2.separate_bodies()
  Polyline3.separate_bodies()
  Polyline4_1.separate_bodies()
  Polyline6_1.separate_bodies()
  Polyline7_1.separate_bodies()
  Polyline8_1.separate_bodies()
  strip1_1_ObjectFromEdge1_Separate7, strip1_1_ObjectFromEdge1_Separate1..strip1_1_ObjectFromEdge1_Separate6 = strip1_1_ObjectFromEdge1.separate_bodies()
  strip2_1_ObjectFromEdge1_Separate7, strip2_1_ObjectFromEdge1_Separate1..strip2_1_ObjectFromEdge1_Separate6 = strip2_1_ObjectFromEdge1.separate_bodies()
  strip3_1_ObjectFromEdge1_Separate7, strip3_1_ObjectFromEdge1_Separate1..strip3_1_ObjectFromEdge1_Separate6 = strip3_1_ObjectFromEdge1.separate_bodies()
  strip4_1_ObjectFromEdge1_Separate7, strip4_1_ObjectFromEdge1_Separate1..strip4_1_ObjectFromEdge1_Separate6 = strip4_1_ObjectFromEdge1.separate_bodies()
  strip1_2_ObjectFromEdge1_Separate7, strip1_2_ObjectFromEdge1_Separate1..strip1_2_ObjectFromEdge1_Separate6 = strip1_2_ObjectFromEdge1.separate_bodies()
  strip2_2_ObjectFromEdge1_Separate7, strip2_2_ObjectFromEdge1_Separate1..strip2_2_ObjectFromEdge1_Separate6 = strip2_2_ObjectFromEdge1.separate_bodies()
  strip3_2_ObjectFromEdge1_Separate7, strip3_2_ObjectFromEdge1_Separate1..strip3_2_ObjectFromEdge1_Separate6 = strip3_2_ObjectFromEdge1.separate_bodies()
  strip4_2_ObjectFromEdge1_Separate7, strip4_2_ObjectFromEdge1_Separate1..strip4_2_ObjectFromEdge1_Separate6 = strip4_2_ObjectFromEdge1.separate_bodies()
  Source1_1_Separate1.separate_bodies()
  Source1_1_Separate2.separate_bodies()
  Source1_1_Separate3.separate_bodies()
  Source1_1_Separate4.separate_bodies()
  Source1_1_Separate5.separate_bodies()
  Source1_1_Separate6.separate_bodies()
  Source1_1_Separate7.separate_bodies()
  Source2_1_Separate1.separate_bodies()
  Source2_1_Separate2.separate_bodies()
  Source2_1_Separate3.separate_bodies()
  Source2_1_Separate4.separate_bodies()
  Source2_1_Separate5.separate_bodies()
  Source2_1_Separate6.separate_bodies()
  Source2_1_Separate7.separate_bodies()
  Source3_1_Separate1.separate_bodies()
  Source3_1_Separate2.separate_bodies()
  Source3_1_Separate3.separate_bodies()
  Source3_1_Separate4.separate_bodies()
  Source3_1_Separate5.separate_bodies()
  Source3_1_Separate6.separate_bodies()
  Source3_1_Separate7.separate_bodies()
  Source4_1_Separate1.separate_bodies()
  Source4_1_Separate2.separate_bodies()
  Source4_1_Separate3.separate_bodies()
  Source4_1_Separate4.separate_bodies()
  Source4_1_Separate5.separate_bodies()
  Source4_1_Separate6.separate_bodies()
  Source4_1_Separate7.separate_bodies()
  Polyline3_Separate1.separate_bodies()
  Polyline3_Separate2.separate_bodies()
  Polyline3_Separate3.separate_bodies()
  Polyline3_Separate4.separate_bodies()
  Polyline3_Separate5.separate_bodies()
  Polyline3_Separate6.separate_bodies()
  Polyline3_Separate7.separate_bodies()
  Polyline2_Separate1.separate_bodies()
  Polyline2_Separate2.separate_bodies()
  Polyline2_Separate3.separate_bodies()
  Polyline2_Separate4.separate_bodies()
  Polyline2_Separate5.separate_bodies()
  Polyline2_Separate6.separate_bodies()
  Polyline2_Separate7.separate_bodies()
  Polyline4_1_Separate1.separate_bodies()
  Polyline4_1_Separate2.separate_bodies()
  Polyline4_1_Separate3.separate_bodies()
  Polyline4_1_Separate4.separate_bodies()
  Polyline4_1_Separate5.separate_bodies()
  Polyline4_1_Separate6.separate_bodies()
  Polyline4_1_Separate7.separate_bodies()
  Polyline7_1_Separate1.separate_bodies()
  Polyline7_1_Separate2.separate_bodies()
  Polyline7_1_Separate3.separate_bodies()
  Polyline7_1_Separate4.separate_bodies()
  Polyline7_1_Separate5.separate_bodies()
  Polyline7_1_Separate6.separate_bodies()
  Polyline7_1_Separate7.separate_bodies()
  Polyline8_1_Separate1.separate_bodies()
  Polyline8_1_Separate2.separate_bodies()
  Polyline8_1_Separate3.separate_bodies()
  Polyline8_1_Separate4.separate_bodies()
  Polyline8_1_Separate5.separate_bodies()
  Polyline8_1_Separate6.separate_bodies()
  Polyline8_1_Separate7.separate_bodies()
  Polyline6_1_Separate1.separate_bodies()
  Polyline6_1_Separate2.separate_bodies()
  Polyline6_1_Separate3.separate_bodies()
  Polyline6_1_Separate4.separate_bodies()
  Polyline6_1_Separate5.separate_bodies()
  Polyline6_1_Separate6.separate_bodies()
  Polyline6_1_Separate7.separate_bodies()
  Source1_2_Separate1.separate_bodies()
  Source1_2_Separate2.separate_bodies()
  Source1_2_Separate3.separate_bodies()
  Source1_2_Separate4.separate_bodies()
  Source1_2_Separate5.separate_bodies()
  Source1_2_Separate6.separate_bodies()
  Source1_2_Separate7.separate_bodies()
  Source2_2_Separate1.separate_bodies()
  Source2_2_Separate2.separate_bodies()
  Source2_2_Separate3.separate_bodies()
  Source2_2_Separate4.separate_bodies()
  Source2_2_Separate5.separate_bodies()
  Source2_2_Separate6.separate_bodies()
  Source2_2_Separate7.separate_bodies()
  Source3_2_Separate1.separate_bodies()
  Source3_2_Separate2.separate_bodies()
  Source3_2_Separate3.separate_bodies()
  Source3_2_Separate4.separate_bodies()
  Source3_2_Separate5.separate_bodies()
  Source3_2_Separate6.separate_bodies()
  Source3_2_Separate7.separate_bodies()
  Source4_2_Separate1.separate_bodies()
  Source4_2_Separate2.separate_bodies()
  Source4_2_Separate3.separate_bodies()
  Source4_2_Separate4.separate_bodies()
  Source4_2_Separate5.separate_bodies()
  Source4_2_Separate6.separate_bodies()
  Source4_2_Separate7.separate_bodies()
  strip1_1_Separate1.separate_bodies()
  strip1_1_Separate2.separate_bodies()
  strip1_1_Separate3.separate_bodies()
  strip1_1_Separate4.separate_bodies()
  strip1_1_Separate5.separate_bodies()
  strip1_1_Separate6.separate_bodies()
  strip1_1_Separate7.separate_bodies()
  Ch1CS1 [non-model] = polyline((77.904193mm, 119.31968mm, 86.5mm) (95.671816mm, 146.53294mm, 86.5mm))
  Ch1CS2 [non-model] = polyline((65.241206mm, 126.68794mm, 86.5mm) (80.120779mm, 155.58169mm, 86.5mm))
  Ch1CS3 [non-model] = polyline((43.449405mm, 135.7144mm, 86.5mm) (53.358918mm, 166.66681mm, 86.5mm))
  Ch1CS4 [non-model] = polyline((29.285174mm, 139.45834mm, 86.5mm) (35.964249mm, 171.26463mm, 86.5mm))
  Ch2CS1 [non-model] = polyline((139.45834mm, 29.285174mm, 86.5mm) (171.26463mm, 35.964249mm, 86.5mm))
  Ch2CS2 [non-model] = polyline((135.7144mm, 43.449405mm, 86.5mm) (166.66681mm, 53.358918mm, 86.5mm))
  Ch2CS3 [non-model] = polyline((126.68794mm, 65.241206mm, 86.5mm) (155.58169mm, 80.120779mm, 86.5mm))
  Ch2CS4 [non-model] = polyline((119.31968mm, 77.904193mm, 86.5mm) (146.53294mm, 95.671816mm, 86.5mm))
  Ch4CS1 [non-model] = polyline((29.285174mm, -139.45834mm, 86.5mm) (35.964249mm, -171.26463mm, 86.5mm))
  Ch4CS2 [non-model] = polyline((43.449405mm, -135.7144mm, 86.5mm) (53.358918mm, -166.66681mm, 86.5mm))
  Ch4CS3 [non-model] = polyline((65.241206mm, -126.68794mm, 86.5mm) (80.120779mm, -155.58169mm, 86.5mm))
  Ch4CS4 [non-model] = polyline((77.904193mm, -119.31968mm, 86.5mm) (95.671816mm, -146.53294mm, 86.5mm))
  Ch5CS1 [non-model] = polyline((-77.904193mm, -119.31968mm, 86.5mm) (-95.671816mm, -146.53294mm, 86.5mm))
  Ch5CS2 [non-model] = polyline((-65.241206mm, -126.68794mm, 86.5mm) (-80.120779mm, -155.58169mm, 86.5mm))
  Ch5CS3 [non-model] = polyline((-43.449405mm, -135.7144mm, 86.5mm) (-53.358918mm, -166.66681mm, 86.5mm))
  Ch5CS4 [non-model] = polyline((-29.285174mm, -139.45834mm, 86.5mm) (-35.964249mm, -171.26463mm, 86.5mm))
  Ch6CS1 [non-model] = polyline((-139.45834mm, -29.285174mm, 86.5mm) (-171.26463mm, -35.964249mm, 86.5mm))
  Ch6CS2 [non-model] = polyline((-135.7144mm, -43.449405mm, 86.5mm) (-166.66681mm, -53.358918mm, 86.5mm))
  Ch6CS3 [non-model] = polyline((-126.68794mm, -65.241206mm, 86.5mm) (-155.58169mm, -80.120779mm, 86.5mm))
  Ch6CS4 [non-model] = polyline((-119.31968mm, -77.904193mm, 86.5mm) (-146.53294mm, -95.671816mm, 86.5mm))
  Ch7CS1 [non-model] = polyline((-119.31968mm, 77.904193mm, 86.5mm) (-146.53294mm, 95.671816mm, 86.5mm))
  Ch7CS2 [non-model] = polyline((-126.68794mm, 65.241206mm, 86.5mm) (-155.58169mm, 80.120779mm, 86.5mm))
  Ch7CS3 [non-model] = polyline((-135.7144mm, 43.449405mm, 86.5mm) (-166.66681mm, 53.358918mm, 86.5mm))
  Ch7CS4 [non-model] = polyline((-139.45834mm, 29.285174mm, 86.5mm) (-171.26463mm, 35.964249mm, 86.5mm))
  Ch8CS1 [non-model] = polyline((-29.285174mm, 139.45834mm, 86.5mm) (-35.964249mm, 171.26463mm, 86.5mm))
  Ch8CS2 [non-model] = polyline((-43.449405mm, 135.7144mm, 86.5mm) (-53.358918mm, 166.66681mm, 86.5mm))
  Ch8CS3 [non-model] = polyline((-65.241206mm, 126.68794mm, 86.5mm) (-80.120779mm, 155.58169mm, 86.5mm))
  Ch8CS4 [non-model] = polyline((-77.904193mm, 119.31968mm, 86.5mm) (-95.671816mm, 146.53294mm, 86.5mm))
  Ch1CS5 [non-model] = polyline((73.768249mm, 121.92004mm, 80.5mm) (69.545599mm, 124.37709mm, 80.5mm))
  Ch1CS6 [non-model] = polyline((60.860128mm, 128.84989mm, 80.5mm) (48.076024mm, 134.14524mm, 80.5mm))
  Ch1CS7 [non-model] = polyline((38.771716mm, 137.12405mm, 80.5mm) (34.048455mm, 138.37251mm, 80.5mm))
  Ch2CS5 [non-model] = polyline((138.37251mm, 34.048455mm, 80.5mm) (137.12405mm, 38.771716mm, 80.5mm))
  Ch2CS6 [non-model] = polyline((134.14524mm, 48.076024mm, 80.5mm) (128.84989mm, 60.860128mm, 80.5mm))
  Ch2CS7 [non-model] = polyline((124.37709mm, 69.545599mm, 80.5mm) (121.92004mm, 73.768249mm, 80.5mm))
  Ch4CS5 [non-model] = polyline((34.048455mm, -138.37251mm, 80.5mm) (38.771716mm, -137.12405mm, 80.5mm))
  Ch4CS6 [non-model] = polyline((48.076024mm, -134.14524mm, 80.5mm) (60.860128mm, -128.84989mm, 80.5mm))
  Ch4CS7 [non-model] = polyline((69.545599mm, -124.37709mm, 80.5mm) (73.768249mm, -121.92004mm, 80.5mm))
  Ch5CS5 [non-model] = polyline((-73.768249mm, -121.92004mm, 80.5mm) (-69.545599mm, -124.37709mm, 80.5mm))
  Ch5CS6 [non-model] = polyline((-60.860128mm, -128.84989mm, 80.5mm) (-48.076024mm, -134.14524mm, 80.5mm))
  Ch5CS7 [non-model] = polyline((-38.771716mm, -137.12405mm, 80.5mm) (-34.048455mm, -138.37251mm, 80.5mm))
  Ch6CS5 [non-model] = polyline((-138.37251mm, -34.048455mm, 80.5mm) (-137.12405mm, -38.771716mm, 80.5mm))
  Ch6CS6 [non-model] = polyline((-134.14524mm, -48.076024mm, 80.5mm) (-128.84989mm, -60.860128mm, 80.5mm))
  Ch6CS7 [non-model] = polyline((-124.37709mm, -69.545599mm, 80.5mm) (-121.92004mm, -73.768249mm, 80.5mm))
  Ch7CS5 [non-model] = polyline((-121.92004mm, 73.768249mm, 80.5mm) (-124.37709mm, 69.545599mm, 80.5mm))
  Ch7CS6 [non-model] = polyline((-128.84989mm, 60.860128mm, 80.5mm) (-134.14524mm, 48.076024mm, 80.5mm))
  Ch7CS7 [non-model] = polyline((-137.12405mm, 38.771716mm, 80.5mm) (-138.37251mm, 34.048455mm, 80.5mm))
  Ch8CS5 [non-model] = polyline((-34.048455mm, 138.37251mm, 80.5mm) (-38.771716mm, 137.12405mm, 80.5mm))
  Ch8CS6 [non-model] = polyline((-48.076024mm, 134.14524mm, 80.5mm) (-60.860128mm, 128.84989mm, 80.5mm))
  Ch8CS7 [non-model] = polyline((-69.545599mm, 124.37709mm, 80.5mm) (-73.768249mm, 121.92004mm, 80.5mm))
  Ch1CS1_bottom [non-model] = polyline((95.671816mm, 146.53294mm, -86.5mm) (77.904193mm, 119.31968mm, -86.5mm))
  Ch1CS2_bottom [non-model] = polyline((80.120779mm, 155.58169mm, -86.5mm) (65.241206mm, 126.68794mm, -86.5mm))
  Ch1CS3_bottom [non-model] = polyline((53.358918mm, 166.66681mm, -86.5mm) (43.449405mm, 135.7144mm, -86.5mm))
  Ch1CS4_bottom [non-model] = polyline((35.964249mm, 171.26463mm, -86.5mm) (29.285174mm, 139.45834mm, -86.5mm))
  Ch1CS5_bottom [non-model] = polyline((73.768249mm, 121.92004mm, -80.5mm) (69.545599mm, 124.37709mm, -80.5mm))
  Ch1CS6_bottom [non-model] = polyline((60.860128mm, 128.84989mm, -80.5mm) (48.076024mm, 134.14524mm, -80.5mm))
  Ch1CS7_bottom [non-model] = polyline((38.771716mm, 137.12405mm, -80.5mm) (34.048455mm, 138.37251mm, -80.5mm))
  ch3cs1 [non-model] = polyline((146.53294mm, -95.671816mm, 86.5mm) (119.31968mm, -77.904193mm, 86.5mm))
  ch3cs2 [non-model] = polyline((155.58169mm, -80.120779mm, 86.5mm) (126.68794mm, -65.241206mm, 86.5mm))
  ch3cs3 [non-model] = polyline((135.7144mm, -43.449405mm, 86.5mm) (166.66681mm, -53.358918mm, 86.5mm))
  ch3cs4 [non-model] = polyline((139.45834mm, -29.285174mm, 86.5mm) (171.26463mm, -35.964249mm, 86.5mm))
  ch3cs5 [non-model] = polyline((121.92004mm, -73.768249mm, 80.5mm) (124.37709mm, -69.545599mm, 80.5mm))
  ch3cs6 [non-model] = polyline((128.84989mm, -60.860128mm, 80.5mm) (134.14524mm, -48.076024mm, 80.5mm))
  ch3cs7 [non-model] = polyline((137.12405mm, -38.771716mm, 80.5mm) (138.37251mm, -34.048455mm, 80.5mm))
boundaries and excitations:
  Rad1: Radiation Objects=Region
  FiniteCond1: Finite Conductivity Objects=[strip4_2_Separate6, strip4_2_Separate7, strip4_2_Separate5, strip4_2_Separate4, strip4_2_Separate3, strip4_2_Separate2, strip4_2_Separate1, strip4_2, strip4_1_Separate7, strip4_1_Separate6, strip4_1_Separate5, strip4_1_Separate4, strip4_1_Separate3, strip4_1_Separate2, strip4_1_Separate1, strip4_1, strip3_2_Separate7, strip3_2_Separate6, strip3_2_Separate5, strip3_2_Separate4, strip3_2_Separate3, strip3_2_Separate1, strip3_2_Separate2, strip3_2, strip3_1_Separate7, strip3_1_Separate6, strip3_1_Separate5, strip3_1_Separate3, strip3_1_Separate4, strip3_1_Separate2, strip3_1_Separate1, strip3_1, strip2_2_Separate7, strip2_2_Separate6, strip2_2_Separate5, strip2_2_Separate4, strip2_2_Separate3, strip2_2_Separate2, strip2_2_Separate1, strip2_2, strip2_1_Separate7, strip2_1_Separate6, strip2_1_Separate5, strip2_1_Separate4, strip2_1_Separate3, strip2_1_Separate2, strip2_1_Separate1, strip2_1, strip1_2_Separate7, strip1_2_Separate6, strip1_2_Separate5, strip1_2_Separate4, strip1_2_Separate3, strip1_2_Separate2, strip1_2_Separate1, strip1_2, strip1_1_Separate7, strip1_1_Separate6, strip1_1_Separate5, strip1_1_Separate4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] UseMaterial Material=copper IsInternal
  FiniteCond2: Finite Conductivity Objects=[Polyline2, Polyline2_Separate1..Polyline2_Separate7, Polyline3, Polyline3_Separate1..Polyline3_Separate7, Polyline4_1, Polyline4_1_Separate1..Polyline4_1_Separate7, Polyline6_1, Polyline6_1_Separate1..Polyline6_1_Separate7, Polyline7_1, Polyline7_1_Separate1..Polyline7_1_Separate7, Polyline8_1, Polyline8_1_Separate1..Polyline8_1_Separate7, Source1_1, Source1_1_Separate1..Source1_1_Separate7, Source1_2, Source1_2_Separate1..Source1_2_Separate7, Source2_1, Source2_1_Separate1..Source2_1_Separate7, Source2_2, Source2_2_Separate1..Source2_2_Separate7, Source3_1, Source3_1_Separate1..Source3_1_Separate7, Source3_2, Source3_2_Separate1..Source3_2_Separate7, Source4_1, Source4_1_Separate1..Source4_1_Separate7, Source4_2, Source4_2_Separate1..Source4_2_Separate7] UseMaterial Material=copper IsInternal
  Current1-1: Current Objects=Source1_1 Direction{(95.671816, 146.53294, 86.5) -> (77.904193, 119.31968, 86.5)}
  Current1-2: Current Objects=Source2_1 Direction{(80.120779, 155.58169, 86.5) -> (65.241206, 126.68794, 86.5)}
  Current1-3: Current Objects=Source3_1 Direction{(43.449405, 135.7144, 86.5) -> (53.358918, 166.66681, 86.5)}
  Current1-4: Current Objects=Source4_1 Direction{(29.285174, 139.45834, 86.5) -> (35.964249, 171.26463, 86.5)}
  Current1-5: Current Objects=Source1_2 Direction{(77.904193, 119.31968, -86.5) -> (95.671816, 146.53294, -86.5)}
  Current1-6: Current Objects=Source2_2 Direction{(65.241206, 126.68794, -86.5) -> (80.120779, 155.58169, -86.5)}
  Current1-7: Current Objects=Source3_2 Direction{(53.358918, 166.66681, -86.5) -> (43.449405, 135.7144, -86.5)}
  Current1-8: Current Objects=Source4_2 Direction{(35.964249, 171.26463, -86.5) -> (29.285174, 139.45834, -86.5)}
  Current1-9: Current Objects=Polyline7_1 Direction{(48.076024, 134.14524, -80.5) -> (60.860128, 128.84989, -80.5)}
  Current1-10: Current Objects=Polyline2 Direction{(73.768249, 121.92004, 80.5) -> (69.545599, 124.37709, 80.5)}
  Current1-11: Current Objects=Polyline3 Direction{(60.860128, 128.84989, 80.5) -> (48.076024, 134.14524, 80.5)}
  Current1-12: Current Objects=Polyline4_1 Direction{(38.771716, 137.12405, 80.5) -> (34.048455, 138.37251, 80.5)}
  Current1-13: Current Objects=Polyline8_1 Direction{(69.545599, 124.37709, -80.5) -> (73.768249, 121.92004, -80.5)}
  Current1-14: Current Objects=Polyline6_1 Direction{(34.048455, 138.37251, -80.5) -> (38.771716, 137.12405, -80.5)}
  Current2-1: Current Objects=Source1_1_Separate1 Direction{(171.26463, 35.964249, 86.5) -> (139.45834, 29.285174, 86.5)}
  Current2-2: Current Objects=Source2_1_Separate1 Direction{(166.66681, 53.358918, 86.5) -> (135.7144, 43.449405, 86.5)}
  Current2-3: Current Objects=Source3_1_Separate1 Direction{(126.68794, 65.241206, 86.5) -> (155.58169, 80.120779, 86.5)}
  Current2-4: Current Objects=Source4_1_Separate1 Direction{(119.31968, 77.904193, 86.5) -> (146.53294, 95.671816, 86.5)}
  Current2-5: Current Objects=Source1_2_Separate1 Direction{(139.45834, 29.285174, -86.5) -> (171.26463, 35.964249, -86.5)}
  Current2-6: Current Objects=Source2_2_Separate1 Direction{(135.7144, 43.449405, -86.5) -> (166.66681, 53.358918, -86.5)}
  Current2-7: Current Objects=Source3_2_Separate1 Direction{(155.58169, 80.120779, -86.5) -> (126.68794, 65.241206, -86.5)}
  Current2-8: Current Objects=Source4_2_Separate1 Direction{(146.53294, 95.671816, -86.5) -> (119.31968, 77.904193, -86.5)}
  Current2-9: Current Objects=Polyline7_1_Separate1 Direction{(128.84989, 60.860128, -80.5) -> (134.14524, 48.076024, -80.5)}
  Current2-10: Current Objects=Polyline2_Separate1 Direction{(138.37251, 34.048455, 80.5) -> (137.12405, 38.771716, 80.5)}
  Current2-11: Current Objects=Polyline3_Separate1 Direction{(134.14524, 48.076024, 80.5) -> (128.84989, 60.860128, 80.5)}
  Current2-12: Current Objects=Polyline4_1_Separate1 Direction{(124.37709, 69.545599, 80.5) -> (121.92004, 73.768249, 80.5)}
  Current2-13: Current Objects=Polyline8_1_Separate1 Direction{(137.12405, 38.771716, -80.5) -> (138.37251, 34.048455, -80.5)}
  Current2-14: Current Objects=Polyline6_1_Separate1 Direction{(121.92004, 73.768249, -80.5) -> (124.37709, 69.545599, -80.5)}
  Current3-1: Current Objects=Source1_1_Separate2 Direction{(146.53294, -95.671816, 86.5) -> (119.31968, -77.904193, 86.5)}
  Current3-2: Current Objects=Source2_1_Separate2 Direction{(155.58169, -80.120779, 86.5) -> (126.68794, -65.241206, 86.5)}
  Current3-3: Current Objects=Source3_1_Separate2 Direction{(135.7144, -43.449405, 86.5) -> (166.66681, -53.358918, 86.5)}
  Current3-4: Current Objects=Source4_1_Separate2 Direction{(139.45834, -29.285174, 86.5) -> (171.26463, -35.964249, 86.5)}
  Current3-9: Current Objects=Polyline7_1_Separate2 Direction{(134.14524, -48.076024, -80.5) -> (128.84989, -60.860128, -80.5)}
  Current3-10: Current Objects=Polyline2_Separate2 Direction{(121.92004, -73.768249, 80.5) -> (124.37709, -69.545599, 80.5)}
  Current3-11: Current Objects=Polyline3_Separate2 Direction{(128.84989, -60.860128, 80.5) -> (134.14524, -48.076024, 80.5)}
  Current3-12: Current Objects=Polyline4_1_Separate2 Direction{(137.12405, -38.771716, 80.5) -> (138.37251, -34.048455, 80.5)}
  Current3-13: Current Objects=Polyline8_1_Separate2 Direction{(124.37709, -69.545599, -80.5) -> (121.92004, -73.768249, -80.5)}
  Current3-14: Current Objects=Polyline6_1_Separate2 Direction{(138.37251, -34.048455, -80.5) -> (137.12405, -38.771716, -80.5)}
  Current4-1: Current Objects=Source1_1_Separate3 Direction{(35.964249, -171.26463, 86.5) -> (29.285174, -139.45834, 86.5)}
  Current4-2: Current Objects=Source2_1_Separate3 Direction{(53.358918, -166.66681, 86.5) -> (43.449405, -135.7144, 86.5)}
  Current4-3: Current Objects=Source3_1_Separate3 Direction{(65.241206, -126.68794, 86.5) -> (80.120779, -155.58169, 86.5)}
  Current4-4: Current Objects=Source4_1_Separate3 Direction{(77.904193, -119.31968, 86.5) -> (95.671816, -146.53294, 86.5)}
  Current4-5: Current Objects=Source1_2_Separate3 Direction{(29.285174, -139.45834, -86.5) -> (35.964249, -171.26463, -86.5)}
  Current4-6: Current Objects=Source2_2_Separate3 Direction{(43.449405, -135.7144, -86.5) -> (53.358918, -166.66681, -86.5)}
  Current4-7: Current Objects=Source3_2_Separate3 Direction{(80.120779, -155.58169, -86.5) -> (65.241206, -126.68794, -86.5)}
  Current4-8: Current Objects=Source4_2_Separate3 Direction{(95.671816, -146.53294, -86.5) -> (77.904193, -119.31968, -86.5)}
  Current4-9: Current Objects=Polyline7_1_Separate3 Direction{(60.860128, -128.84989, -80.5) -> (48.076024, -134.14524, -80.5)}
  Current4-10: Current Objects=Polyline2_Separate3 Direction{(34.048455, -138.37251, 80.5) -> (38.771716, -137.12405, 80.5)}
  Current4-11: Current Objects=Polyline3_Separate3 Direction{(48.076024, -134.14524, 80.5) -> (60.860128, -128.84989, 80.5)}
  Current4-12: Current Objects=Polyline4_1_Separate3 Direction{(69.545599, -124.37709, 80.5) -> (73.768249, -121.92004, 80.5)}
  Current4-13: Current Objects=Polyline8_1_Separate3 Direction{(38.771716, -137.12405, -80.5) -> (34.048455, -138.37251, -80.5)}
  Current4-14: Current Objects=Polyline6_1_Separate3 Direction{(73.768249, -121.92004, -80.5) -> (69.545599, -124.37709, -80.5)}
  Current5-1: Current Objects=Source1_1_Separate4 Direction{(-95.671816, -146.53294, 86.5) -> (-77.904193, -119.31968, 86.5)}
  Current5-2: Current Objects=Source2_1_Separate4 Direction{(-80.120779, -155.58169, 86.5) -> (-65.241206, -126.68794, 86.5)}
  Current5-3: Current Objects=Source3_1_Separate4 Direction{(-43.449405, -135.7144, 86.5) -> (-53.358918, -166.66681, 86.5)}
  Current5-4: Current Objects=Source4_1_Separate4 Direction{(-29.285174, -139.45834, 86.5) -> (-35.964249, -171.26463, 86.5)}
  Current5-5: Current Objects=Source1_2_Separate4 Direction{(-77.904193, -119.31968, -86.5) -> (-95.671816, -146.53294, -86.5)}
  Current5-6: Current Objects=Source2_2_Separate4 Direction{(-65.241206, -126.68794, -86.5) -> (-80.120779, -155.58169, -86.5)}
  Current5-7: Current Objects=Source3_2_Separate4 Direction{(-53.358918, -166.66681, -86.5) -> (-43.449405, -135.7144, -86.5)}
  Current5-8: Current Objects=Source4_2_Separate4 Direction{(-35.964249, -171.26463, -86.5) -> (-29.285174, -139.45834, -86.5)}
  Current5-9: Current Objects=Polyline7_1_Separate4 Direction{(-48.076024, -134.14524, -80.5) -> (-60.860128, -128.84989, -80.5)}
  Current5-10: Current Objects=Polyline2_Separate4 Direction{(-73.768249, -121.92004, 80.5) -> (-69.545599, -124.37709, 80.5)}
  Current5-11: Current Objects=Polyline3_Separate4 Direction{(-60.860128, -128.84989, 80.5) -> (-48.076024, -134.14524, 80.5)}
  Current5-12: Current Objects=Polyline4_1_Separate4 Direction{(-38.771716, -137.12405, 80.5) -> (-34.048455, -138.37251, 80.5)}
  Current5-13: Current Objects=Polyline8_1_Separate4 Direction{(-69.545599, -124.37709, -80.5) -> (-73.768249, -121.92004, -80.5)}
  Current5-14: Current Objects=Polyline6_1_Separate4 Direction{(-34.048455, -138.37251, -80.5) -> (-38.771716, -137.12405, -80.5)}
  Current3-5: Current Objects=Source1_2_Separate2 Direction{(119.31968, -77.904193, -86.5) -> (146.53294, -95.671816, -86.5)}
  Current3-6: Current Objects=Source2_2_Separate2 Direction{(126.68794, -65.241206, -86.5) -> (155.58169, -80.120779, -86.5)}
  Current3-7: Current Objects=Source3_2_Separate2 Direction{(166.66681, -53.358918, -86.5) -> (135.7144, -43.449405, -86.5)}
  Current3-8: Current Objects=Source4_2_Separate2 Direction{(171.26463, -35.964249, -86.5) -> (139.45834, -29.285174, -86.5)}
  Current6-1: Current Objects=Source1_1_Separate5 Direction{(-171.26463, -35.964249, 86.5) -> (-139.45834, -29.285174, 86.5)}
  Current6-2: Current Objects=Source2_1_Separate5 Direction{(-166.66681, -53.358918, 86.5) -> (-135.7144, -43.449405, 86.5)}
  Current6-3: Current Objects=Source3_1_Separate5 Direction{(-126.68794, -65.241206, 86.5) -> (-155.58169, -80.120779, 86.5)}
  Current6-4: Current Objects=Source4_1_Separate5 Direction{(-119.31968, -77.904193, 86.5) -> (-146.53294, -95.671816, 86.5)}
  Current6-5: Current Objects=Source1_2_Separate5 Direction{(-139.45834, -29.285174, -86.5) -> (-171.26463, -35.964249, -86.5)}
  Current6-6: Current Objects=Source2_2_Separate5 Direction{(-135.7144, -43.449405, -86.5) -> (-166.66681, -53.358918, -86.5)}
  Current6-7: Current Objects=Source3_2_Separate5 Direction{(-155.58169, -80.120779, -86.5) -> (-126.68794, -65.241206, -86.5)}
  Current6-8: Current Objects=Source4_2_Separate5 Direction{(-146.53294, -95.671816, -86.5) -> (-119.31968, -77.904193, -86.5)}
  Current6-9: Current Objects=Polyline7_1_Separate5 Direction{(-128.84989, -60.860128, -80.5) -> (-134.14524, -48.076024, -80.5)}
  Current6-10: Current Objects=Polyline2_Separate5 Direction{(-138.37251, -34.048455, 80.5) -> (-137.12405, -38.771716, 80.5)}
  Current6-11: Current Objects=Polyline3_Separate5 Direction{(-134.14524, -48.076024, 80.5) -> (-128.84989, -60.860128, 80.5)}
  Current6-12: Current Objects=Polyline4_1_Separate5 Direction{(-124.37709, -69.545599, 80.5) -> (-121.92004, -73.768249, 80.5)}
  Current6-13: Current Objects=Polyline8_1_Separate5 Direction{(-137.12405, -38.771716, -80.5) -> (-138.37251, -34.048455, -80.5)}
  Current6-14: Current Objects=Polyline6_1_Separate5 Direction{(-121.92004, -73.768249, -80.5) -> (-124.37709, -69.545599, -80.5)}
  Current7-1: Current Objects=Source1_1_Separate6 Direction{(-146.53294, 95.671816, 86.5) -> (-119.31968, 77.904193, 86.5)}
  Current7-2: Current Objects=Source2_1_Separate6 Direction{(-155.58169, 80.120779, 86.5) -> (-126.68794, 65.241206, 86.5)}
  Current7-3: Current Objects=Source3_1_Separate6 Direction{(-135.7144, 43.449405, 86.5) -> (-166.66681, 53.358918, 86.5)}
  Current7-4: Current Objects=Source4_1_Separate6 Direction{(-139.45834, 29.285174, 86.5) -> (-171.26463, 35.964249, 86.5)}
  Current7-5: Current Objects=Source1_2_Separate6 Direction{(-119.31968, 77.904193, -86.5) -> (-146.53294, 95.671816, -86.5)}
  Current7-6: Current Objects=Source2_2_Separate6 Direction{(-126.68794, 65.241206, -86.5) -> (-155.58169, 80.120779, -86.5)}
  Current7-7: Current Objects=Source3_2_Separate6 Direction{(-166.66681, 53.358918, -86.5) -> (-135.7144, 43.449405, -86.5)}
  Current7-8: Current Objects=Source4_2_Separate6 Direction{(-171.26463, 35.964249, -86.5) -> (-139.45834, 29.285174, -86.5)}
  Current7-9: Current Objects=Polyline7_1_Separate6 Direction{(-134.14524, 48.076024, -80.5) -> (-128.84989, 60.860128, -80.5)}
  Current7-10: Current Objects=Polyline2_Separate6 Direction{(-121.92004, 73.768249, 80.5) -> (-124.37709, 69.545599, 80.5)}
  Current7-11: Current Objects=Polyline3_Separate6 Direction{(-128.84989, 60.860128, 80.5) -> (-134.14524, 48.076024, 80.5)}
  Current7-12: Current Objects=Polyline4_1_Separate6 Direction{(-137.12405, 38.771716, 80.5) -> (-138.37251, 34.048455, 80.5)}
  Current7-13: Current Objects=Polyline8_1_Separate6 Direction{(-124.37709, 69.545599, -80.5) -> (-121.92004, 73.768249, -80.5)}
  Current7-14: Current Objects=Polyline6_1_Separate6 Direction{(-138.37251, 34.048455, -80.5) -> (-137.12405, 38.771716, -80.5)}
  Current8-1: Current Objects=Source1_1_Separate7 Direction{(-35.964249, 171.26463, 86.5) -> (-29.285174, 139.45834, 86.5)}
  Current8-2: Current Objects=Source2_1_Separate7 Direction{(-53.358918, 166.66681, 86.5) -> (-43.449405, 135.7144, 86.5)}
  Current8-3: Current Objects=Source3_1_Separate7 Direction{(-65.241206, 126.68794, 86.5) -> (-80.120779, 155.58169, 86.5)}
  Current8-4: Current Objects=Source4_1_Separate7 Direction{(-77.904193, 119.31968, 86.5) -> (-95.671816, 146.53294, 86.5)}
  Current8-5: Current Objects=Source1_2_Separate7 Direction{(-29.285174, 139.45834, -86.5) -> (-35.964249, 171.26463, -86.5)}
  Current8-6: Current Objects=Source2_2_Separate7 Direction{(-43.449405, 135.7144, -86.5) -> (-53.358918, 166.66681, -86.5)}
  Current8-7: Current Objects=Source3_2_Separate7 Direction{(-80.120779, 155.58169, -86.5) -> (-65.241206, 126.68794, -86.5)}
  Current8-8: Current Objects=Source4_2_Separate7 Direction{(-95.671816, 146.53294, -86.5) -> (-77.904193, 119.31968, -86.5)}
  Current8-9: Current Objects=Polyline7_1_Separate7 Direction{(-60.860128, 128.84989, -80.5) -> (-48.076024, 134.14524, -80.5)}
  Current8-10: Current Objects=Polyline2_Separate7 Direction{(-34.048455, 138.37251, 80.5) -> (-38.771716, 137.12405, 80.5)}
  Current8-11: Current Objects=Polyline3_Separate7 Direction{(-48.076024, 134.14524, 80.5) -> (-60.860128, 128.84989, 80.5)}
  Current8-12: Current Objects=Polyline4_1_Separate7 Direction{(-69.545599, 124.37709, 80.5) -> (-73.768249, 121.92004, 80.5)}
  Current8-13: Current Objects=Polyline8_1_Separate7 Direction{(-38.771716, 137.12405, -80.5) -> (-34.048455, 138.37251, -80.5)}
  Current8-14: Current Objects=Polyline6_1_Separate7 Direction{(-73.768249, 121.92004, -80.5) -> (-69.545599, 124.37709, -80.5)}
mesh:
  RFCOIL: LengthBased Objects=[strip1_1_Separate1..strip1_1_Separate7, strip1_2, strip1_2_Separate1..strip1_2_Separate7, strip2_1, strip2_1_Separate1..strip2_1_Separate7, strip2_2, strip2_2_Separate1..strip2_2_Separate7, strip3_1, strip3_1_Separate1..strip3_1_Separate7, strip3_2, strip3_2_Separate1..strip3_2_Separate7, strip4_1, strip4_1_Separate1..strip4_1_Separate7, strip4_2, strip4_2_Separate1..strip4_2_Separate7, strip1_1] MaxLength=5mm
  region: LengthBased RefineInside Objects=Region MaxLength=50mm
  phantom: LengthBased RefineInside Objects=phantom1 MaxLength=10mm
setups:
  Setup1: HfssDriven Frequency=298MHz MaxDeltaE=0.02 MaximumPasses=12 MinimumPasses=1 MinimumConvergedPasses=1 PercentRefinement=20 BasisOrder=1 DrivenSolverType="Direct Solver"
    sweep Sweep: 298MHz to 298MHz step 0.18MHz; Type=Discrete SaveFields
source amplitudes:
  Current1-1:1: UM11 UP11+PI1
  Current1-2:1: UM12 UP12+PI1
  Current1-3:1: UM13 UP13+PI1
  Current1-4:1: UM14 UP14+PI1
  Current1-5:1: LM11 LP11+PI1
  Current1-6:1: LM12 LP12+PI1
  Current1-7:1: LM13 LP13+PI1
  Current1-8:1: LM14 LP14+PI1
  Current1-9:1: LM16 LP16+PI1
  Current1-10:1: UM15 UP15+PI1
  Current1-11:1: UM16 UP16+PI1
  Current1-12:1: UM17 UP17+PI1
  Current1-13:1: LM15 LP15+PI1
  Current1-14:1: LM17 LP17+PI1
  Current2-1:1: UM21 UP21+PI2
  Current2-2:1: UM22 UP22+PI2
  Current2-3:1: UM23 UP23+PI2
  Current2-4:1: UM24 UP24+PI2
  Current2-5:1: LM21 LP21+PI2
  Current2-6:1: LM22 LP22+PI2
  Current2-7:1: LM23 LP23+PI2
  Current2-8:1: LM24 LP24+PI2
  Current2-9:1: LM26 LP26+PI2
  Current2-10:1: UM25 UP25+PI2
  Current2-11:1: UM26 UP26+PI2
  Current2-12:1: UM27 UP27+PI2
  Current2-13:1: LM25 LP25+PI2
  Current2-14:1: LM27 LP27+PI2
  Current3-1:1: UM31 UP31+PI3
  Current3-2:1: UM32 UP32+PI3
  Current3-3:1: UM33 UP33+PI3
  Current3-4:1: UM34 UP34+PI3
  Current3-9:1: LM36 LP36+PI3
  Current3-10:1: UM35 UP35+PI3
  Current3-11:1: UM36 UP36+PI3
  Current3-12:1: UM37 UP37+PI3
  Current3-13:1: LM35 LP35+PI3
  Current3-14:1: LM37 LP37+PI3
  Current4-1:1: UM41 UP41+PI4
  Current4-2:1: UM42 UP42+PI4
  Current4-3:1: UM43 UP43+PI4
  Current4-4:1: UM44 UP44+PI4
  Current4-5:1: LM41 LP41+PI4
  Current4-6:1: LM42 LP42+PI4
  Current4-7:1: LM43 LP43+PI4
  Current4-8:1: LM44 LP44+PI4
  Current4-9:1: LM46 LP46+PI4
  Current4-10:1: UM45 UP45+PI4
  Current4-11:1: UM46 UP46+PI4
  Current4-12:1: UM47 UP47+PI4
  Current4-13:1: LM45 LP45+PI4
  Current4-14:1: LM47 LP47+PI4
  Current5-1:1: UM51 UP51+PI5
  Current5-2:1: UM52 UP52+PI5
  Current5-3:1: UM53 UP53+PI5
  Current5-4:1: UM54 UP54+PI5
  Current5-5:1: LM51 LP51+PI5
  Current5-6:1: LM52 LP52+PI5
  Current5-7:1: LM53 LP53+PI5
  Current5-8:1: LM54 LP54+PI5
  Current5-9:1: LM56 LP56+PI5
  Current5-10:1: UM55 UP55+PI5
  Current5-11:1: UM56 UP56+PI5
  Current5-12:1: UM57 UP57+PI5
  Current5-13:1: LM55 LP55+PI5
  Current5-14:1: LM57 LP57+PI5
  Current3-5:1: LM31 LP31+PI3
  Current3-6:1: LM32 LP32+PI3
  Current3-7:1: LM33 LP33+PI3
  Current3-8:1: LM34 LP34+PI3
  Current6-1:1: UM61 UP61+PI6
  Current6-2:1: UM62 UP62+PI6
  Current6-3:1: UM63 UP63+PI6
  Current6-4:1: UM64 UP64+PI6
  Current6-5:1: LM61 LP61+PI6
  Current6-6:1: LM62 LP62+PI6
  Current6-7:1: LM63 LP63+PI6
  Current6-8:1: LM64 LP64+PI6
  Current6-9:1: LM66 LP66+PI6
  Current6-10:1: UM65 UP65+PI6
  Current6-11:1: UM66 UP66+PI6
  Current6-12:1: UM67 UP67+PI6
  Current6-13:1: LM65 LP65+PI6
  Current6-14:1: LM67 LP67+PI6
  Current7-1:1: UM71 UP71+PI7
  Current7-2:1: UM72 UP72+PI7
  Current7-3:1: UM73 UP73+PI7
  Current7-4:1: UM74 UP74+PI7
  Current7-5:1: LM71 LP71+PI7
  Current7-6:1: LM72 LP72+PI7
  Current7-7:1: LM73 LP73+PI7
  Current7-8:1: LM74 LP74+PI7
  Current7-9:1: LM76 LP76+PI7
  Current7-10:1: UM75 UP75+PI7
  Current7-11:1: UM76 UP76+PI7
  Current7-12:1: UM77 UP77+PI7
  Current7-13:1: LM75 LP75+PI7
  Current7-14:1: LM77 LP77+PI7
  Current8-1:1: UM81 UP81+PI8
  Current8-2:1: UM82 UP82+PI8
  Current8-3:1: UM83 UP83+PI8
  Current8-4:1: UM84 UP84+PI8
  Current8-5:1: LM81 LP81+PI8
  Current8-6:1: LM82 LP82+PI8
  Current8-7:1: LM83 LP83+PI8
  Current8-8:1: LM84 LP84+PI8
  Current8-9:1: LM86 LP86+PI8
  Current8-10:1: UM85 UP85+PI8
  Current8-11:1: UM86 UP86+PI8
  Current8-12:1: UM87 UP87+PI8
  Current8-13:1: LM85 LP85+PI8
  Current8-14:1: LM87 LP87+PI8
output variables:
  BrealX = H
field calculator expressions:
  CmplxMag_B1P = <Hx,Hy,Hz> | ScalarX | <Hx,Hy,Hz> | ScalarY | Complex_Constant(0, 1) | * | + | Complex_Constant(0.5, 0) | * | CmplxMag | 1.25664e-06 | *
  P = Fundamental_Quantity(0) | Mag | 2 | Pow | 0.5 | * | EnterVolume(phantom1) | VolumeValue | Integrate
  B1E = CmplxMag_B1P | P | Sqrt | /
  B1PP = CmplxMag_B1P | P | /
  B = <Hx,Hy,Hz> | Smooth | 1.25663706143592e-06 | *
  BimagX = B | Imag | ScalarX
  BimagY = B | Imag | ScalarY
  BimagZ = B | Imag | ScalarZ
  BrealX = B | Real | ScalarX
  BrealY = B | Real | ScalarY
  BrealZ = B | Real | ScalarZ
  bm = B | Mag
  Jszr = Fundamental_Quantity(1) | ScalarZ | Real
  Jszi = Fundamental_Quantity(1) | ScalarZ | Imag
  strp11 = Jszi | EnterLine(strip1_1_ObjectFromEdge1) | LineValue | Integrate | CmplxI | Jszr | EnterLine(strip1_1_ObjectFromEdge1) | LineValue | Integrate | CmplxR | +
  strp12 = Jszi | EnterLine(strip1_2_ObjectFromEdge1) | LineValue | Integrate | CmplxI | Jszr | EnterLine(strip1_2_ObjectFromEdge1) | LineValue | Integrate | CmplxR | +
  strp21 = Jszi | EnterLine(strip2_1_ObjectFromEdge1) | LineValue | Integrate | CmplxI | Jszr | EnterLine(strip2_1_ObjectFromEdge1) | LineValue | Integrate | CmplxR | +
  strp22 = Jszi | EnterLine(strip2_2_ObjectFromEdge1) | LineValue | Integrate | CmplxI | Jszr | EnterLine(strip2_2_ObjectFromEdge1) | LineValue | Integrate | CmplxR | +
  strp31 = Jszi | EnterLine(strip3_1_ObjectFromEdge1) | LineValue | Integrate | CmplxI | Jszr | EnterLine(strip3_1_ObjectFromEdge1) | LineValue | Integrate | CmplxR | +
  strp32 = Jszi | EnterLine(strip3_2_ObjectFromEdge1) | LineValue | Integrate | CmplxI | Jszr | EnterLine(strip3_2_ObjectFromEdge1) | LineValue | Integrate | CmplxR | +
  strp41 = Jszi | EnterLine(strip4_1_ObjectFromEdge1) | LineValue | Integrate | CmplxI | Jszr | EnterLine(strip4_1_ObjectFromEdge1) | LineValue | Integrate | CmplxR | +
  strp42 = Jszi | EnterLine(strip4_2_ObjectFromEdge1) | LineValue | Integrate | CmplxI | Jszr | EnterLine(strip4_2_ObjectFromEdge1) | LineValue | Integrate | CmplxR | +
  BF = <Hx,Hy,Hz> | ScalarY | 1.25663706143592e-06 | *
  BMag = B | Mag
  conductivity = Vector_Constant(1, 1, 1) | MaterialOp(Conductivity (cond)) | Smooth | Mag
field plots:
  BMag1: NamedExpr over Rectangle2.face on Setup1 : LastAdaptive at Freq=0.298GHz Phase=0deg
